* Independently derived from analog/highspeed_nrz/voltage_driver.spice
* External resistors excluded; B WTAIL snapped to 5.760 um.
.subckt hs_nrz_voltage_core DATA OUT VDD VH VL VSS
XN1 N1 DATA VSS VSS nfet_03v3 w=1u l=0.28u
XP1 N1 DATA VDD VDD pfet_03v3 w=2u l=0.28u
XN2 CTRL N1 VSS VSS nfet_03v3 w=4u l=0.28u
XP2 CTRL N1 VDD VDD pfet_03v3 w=8u l=0.28u
XNOUT OUT CTRL VL VSS nfet_03v3 w=4u l=0.28u
XPOUT OUT CTRL VH VH pfet_03v3 w=8u l=0.28u
.ends hs_nrz_voltage_core
