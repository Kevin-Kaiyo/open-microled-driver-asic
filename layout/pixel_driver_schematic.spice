* Independent reference for LVS of the same Phase 1 six-MOS circuit.
* Explicit VSS port replaces testbench global node 0; SI W/L units.
* Names nfet_06v0/pfet_06v0 are the pinned full-PDK aliases.
.subckt pixel_driver_layout VSS bias gate pwm pwm_b led_k vlogic
XREF bias bias VSS VSS nfet_06v0 w=20u l=4u
XOUT led_k gate VSS VSS nfet_06v0 w=20u l=4u
XPASS bias pwm gate VSS nfet_06v0 w=2u l=1u
XCLAMP gate pwm_b VSS VSS nfet_06v0 w=2u l=1u
XINV_N pwm_b pwm VSS VSS nfet_06v0 w=2u l=1u
XINV_P pwm_b pwm vlogic vlogic pfet_06v0 w=4u l=1u
.ends pixel_driver_layout
