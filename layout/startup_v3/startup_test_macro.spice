* 39 MOS physical test macro. All four resistors/compensation are external.
* No ideal passive is claimed as manufactured inside this cell.
.include official_buf_2.spice
.subckt startup_test_macro VSS VREF VSAFE VBUF LED_A RAW_PWM FAULT PERMIT VSET SENSE PB N2 CTRL FAULT_HB LED_K REFOUT BIAS GATE PWM_B SAFE_OUT PWM_DRIVE
XR_PBIAS PB PB VREF VREF pfet_06v0 w=20u l=4u
XR_PTAIL R_TAIL PB VREF VREF pfet_06v0 w=20u l=4u
XR_PD1 R_N1 VSET R_TAIL VREF pfet_06v0 w=100u l=10u
XR_PD2 N2 SENSE R_TAIL VREF pfet_06v0 w=100u l=10u
XR_ND1 R_N1 R_N1 VSS VSS nfet_06v0 w=50u l=10u
XR_ND2 N2 R_N1 VSS VSS nfet_06v0 w=50u l=10u
XR_NSTAGE CTRL N2 VSS VSS nfet_06v0 w=20u l=1u
XR_PLOAD CTRL CTRL VREF VREF pfet_06v0 w=100u l=10u
XR_PREG SENSE CTRL VREF VREF pfet_06v0 w=100u l=10u
XR_POUT REFOUT CTRL VREF VREF pfet_06v0 w=100u l=10u
XI_FN I_FAULT_B FAULT VSS VSS nfet_06v0 w=2u l=1u
XI_FP I_FAULT_B FAULT VSAFE VSAFE pfet_06v0 w=4u l=1u
XI_ISO REFOUT I_FAULT_B BIAS VSS nfet_06v0 w=20u l=1u
XI_PISO BIAS FAULT REFOUT VSAFE pfet_06v0 w=20u l=1u
XI_DIS BIAS FAULT VSS VSS nfet_06v0 w=2u l=1u
XF_FN F_FAULT_B FAULT VSS VSS nfet_06v0 w=2u l=1u
XF_FP F_FAULT_B FAULT VSAFE VSAFE pfet_06v0 w=4u l=1u
XF_NP0 F_NAND_N RAW_PWM VSAFE VSAFE pfet_06v0 w=4u l=1u
XF_NP1 F_NAND_N PERMIT VSAFE VSAFE pfet_06v0 w=4u l=1u
XF_NP2 F_NAND_N F_FAULT_B VSAFE VSAFE pfet_06v0 w=4u l=1u
XF_NN0 F_NAND_N RAW_PWM F_STACK1 VSS nfet_06v0 w=6u l=1u
XF_NN1 F_STACK1 PERMIT F_STACK2 VSS nfet_06v0 w=6u l=1u
XF_NN2 F_STACK2 F_FAULT_B VSS VSS nfet_06v0 w=6u l=1u
XF_ON SAFE_OUT F_NAND_N VSS VSS nfet_06v0 w=4u l=1u
XF_OP SAFE_OUT F_NAND_N VSAFE VSAFE pfet_06v0 w=8u l=1u
XC_LN0 FAULT_HB FAULT VSS VSS nfet_06v0 w=2u l=1u
XC_CP LED_K FAULT_HB LED_A LED_A pfet_06v0 w=2u l=1u
XP_REF BIAS BIAS VSS VSS nfet_06v0 w=20u l=4u
XP_OUT LED_K GATE VSS VSS nfet_06v0 w=20u l=4u
XP_PASS BIAS PWM_DRIVE GATE VSS nfet_06v0 w=2u l=1u
XP_CLAMP GATE PWM_B VSS VSS nfet_06v0 w=2u l=1u
XP_INV_N PWM_B PWM_DRIVE VSS VSS nfet_06v0 w=2u l=1u
XP_INV_P PWM_B PWM_DRIVE VBUF VBUF pfet_06v0 w=4u l=1u
XBUF SAFE_OUT PWM_DRIVE VBUF VBUF VSS VSS gf180mcu_fd_sc_mcu7t5v0__buf_2
.ends startup_test_macro
