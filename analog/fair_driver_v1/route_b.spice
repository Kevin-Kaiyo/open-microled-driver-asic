* New schematic-only matched-current NRZ candidate. No inherited PEX qualification.
* All MOS junction estimates use W*0.44um and 2*(W+0.44um); dimensions in meters.
.subckt fair_b D0 D1 OUT VIN VDD VREF VSS DISABLE params: RSET=20k WTAIL=5.76u RINL=8u
XVI VIN VSS VSET SENSE BIAS IPB IN2 ICTRL DISABLE KRET nrz_vi_reference
RTOP VREF VSET 200k
RBOT VSET VSS 50k
RSET1 SENSE VSS {RSET}
RBIAS IPB VSS 100k
RCOMP IN2 CC .5
CCOMP CC VSS 150p
RKEEP OUT KRET 1.8meg
XRIN D0 DI VSS ppolyf_u_1k_6p0 r_width=1u r_length={RINL}
XREF BIAS BIAS VSS VSS nfet_03v3 w=2u l=1u ad=.88p as=.88p pd=4.88u ps=4.88u
XBASE OUT BIAS VSS VSS nfet_03v3 w=2u l=1u ad=.88p as=.88p pd=4.88u ps=4.88u
XTAIL VX BIAS VSS VSS nfet_03v3 w={WTAIL} l=1u ad={WTAIL*.44u} as={WTAIL*.44u} pd={2*(WTAIL+.44u)} ps={2*(WTAIL+.44u)}
XLED OUT GP VX VSS nfet_06v0 w=2.5u l=.7u ad=1.1p as=1.1p pd=5.88u ps=5.88u
XDUMMY DUMMY GB VX VSS nfet_06v0 w=2.5u l=.7u ad=1.1p as=1.1p pd=5.88u ps=5.88u
XINV1N GB DI VSS VSS nfet_06v0 w=2.5u l=.7u ad=1.1p as=1.1p pd=5.88u ps=5.88u
XINV1P GB DI VDD VDD pfet_06v0 w=3.93u l=.55u ad=1.7292p as=1.7292p pd=8.74u ps=8.74u
XINV2N GP GB VSS VSS nfet_06v0 w=2.5u l=.7u ad=1.1p as=1.1p pd=5.88u ps=5.88u
XINV2P GP GB VDD VDD pfet_06v0 w=3.93u l=.55u ad=1.7292p as=1.7292p pd=8.74u ps=8.74u
RDUMMY VIN DUMMY 50k
.ends fair_b
