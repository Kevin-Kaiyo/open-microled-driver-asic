* Static measured I-V curve only; source dataset CC BY 4.0.
* Lin et al. 2026; Zenodo 10.5281/zenodo.20034288; I-V.xlsx Sheet1 A3:B102.
* 20 um square-mesa yellow InGaN on diamond; source temperature unspecified.
* Validated input domain: 0.1 uA .. 32 mA / 2.41622 V .. 6.40451 V.
* No capacitance, optical output, self-heating, leakage or temperature scaling.
* Below first point a line to (0 V,0 A) is a startup extension, not measured data.
* Above last point linear extrapolation is numerical only; reverse response unvalidated.
.subckt lin2026_yellow20_dc anode cathode
BLED anode cathode I = pwl(v(anode,cathode),0,0,
+ 2.41622,1.0000000000000001e-07,2.4289299999999998,1.1366000000000001e-07,2.44164,1.29186e-07,
+ 2.4544000000000001,1.46833e-07,2.4674499999999999,1.6689000000000001e-07,2.48095,1.89687e-07,
+ 2.4942799999999998,2.1559800000000002e-07,2.5083299999999999,2.4504900000000001e-07,2.52291,2.7852299999999996e-07,
+ 2.5375399999999999,3.1656900000000001e-07,2.55246,3.5981199999999999e-07,2.5678700000000001,4.0896200000000003e-07,
+ 2.5831499999999998,4.6482700000000004e-07,2.59883,5.2832200000000006e-07,2.6146699999999998,6.0048999999999995e-07,
+ 2.6314600000000001,6.8251699999999997e-07,2.64873,7.7574899999999991e-07,2.6655199999999999,8.8171600000000008e-07,
+ 2.68391,9.9999999999999995e-07,2.70208,1.1399999999999999e-06,2.7208999999999999,1.2899999999999999e-06,
+ 2.7403,1.4699999999999999e-06,2.76057,1.6700000000000001e-06,2.7814299999999998,1.9e-06,
+ 2.8027799999999998,2.1600000000000001e-06,2.8250500000000001,2.4600000000000002e-06,2.84748,2.79e-06,
+ 2.8709099999999999,3.1700000000000001e-06,2.8951199999999999,3.6100000000000002e-06,2.92062,4.1000000000000006e-06,
+ 2.9466100000000002,4.6600000000000003e-06,2.9732400000000001,5.2900000000000002e-06,3.00109,6.02e-06,
+ 3.02922,6.8399999999999997e-06,3.0582799999999999,7.7700000000000001e-06,3.0886399999999998,8.8400000000000001e-06,
+ 3.1189499999999999,1.004e-05,3.15089,1.1419999999999999e-05,3.1834199999999999,1.2970000000000001e-05,
+ 3.2172299999999998,1.4749999999999999e-05,3.2507999999999999,1.6760000000000002e-05,3.28545,1.9050000000000002e-05,
+ 3.3207100000000001,2.1650000000000001e-05,3.3571399999999998,2.461e-05,3.3933200000000001,2.7969999999999998e-05,
+ 3.43086,3.1789999999999999e-05,3.4696400000000001,3.6139999999999996e-05,3.5081899999999999,4.1070000000000005e-05,
+ 3.5463499999999999,4.668e-05,3.5848100000000001,5.3060000000000004e-05,3.6227399999999998,6.0310000000000004e-05,
+ 3.66032,6.8549999999999999e-05,3.6976200000000001,7.7909999999999991e-05,3.7340800000000001,8.8550000000000011e-05,
+ 3.7698299999999998,0.00010065000000000001,3.8054999999999999,0.0001144,3.84057,0.00013002000000000001,
+ 3.8751899999999999,0.00014779000000000002,3.9097,0.00016797000000000001,3.9438300000000002,0.00019092000000000002,
+ 3.97803,0.00021700000000000002,4.0120100000000001,0.00024664000000000001,4.0459399999999999,0.00028033000000000002,
+ 4.0794800000000002,0.00031862000000000004,4.1136400000000002,0.00036215000000000005,4.1479100000000004,0.00041162000000000002,
+ 4.18222,0.00046783999999999997,4.2166399999999999,0.00053175,4.25143,0.00060439000000000001,
+ 4.28667,0.00068694999999999997,4.3221299999999996,0.00078078000000000002,4.3582599999999996,0.00088743999999999997,
+ 4.3950100000000001,0.00100866,4.4326600000000003,0.0011464399999999999,4.4711299999999996,0.00130305,
+ 4.5104499999999996,0.00148105,4.5509599999999999,0.0016833600000000001,4.5930299999999997,0.0019132999999999999,
+ 4.6366100000000001,0.0021746599999999997,4.6818999999999997,0.0024717200000000002,4.7290099999999997,0.00280935,
+ 4.7780500000000004,0.0031931099999999999,4.8274800000000004,0.0036292900000000003,4.8815999999999997,0.0041250499999999999,
+ 4.9382900000000003,0.0046885299999999998,4.9980200000000004,0.0053289799999999997,5.0607800000000003,0.0060569200000000004,
+ 5.1269600000000004,0.0068842900000000004,5.1972300000000002,0.0078246800000000005,5.2715300000000003,0.0088935300000000002,
+ 5.3503299999999996,0.01010839,5.4342300000000003,0.011489190000000002,5.52407,0.01305861,
+ 5.6205299999999996,0.01484241,5.7246300000000003,0.01686988,5.8373900000000001,0.01917431,
+ 5.9603799999999998,0.021793510000000002,6.0950100000000003,0.024770499999999997,6.2423400000000004,0.028154150000000003,
+ 6.4045100000000001,0.032000000000000001
+ )
.ends lin2026_yellow20_dc
