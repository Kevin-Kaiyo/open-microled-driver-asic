* Independent dual source-sense current servo; finite-gain PMOS-input OTAs.
* VSET and VREGSET are externally supplied precision-voltage boundaries, NOT implemented bandgaps.
* RBASE/RTAIL, compensation, divider and output capacitors are explicit external ideal passive assumptions.
* All MOS use pinned GF180 silicon 3.3V BSIM; no layout/PEX qualification.
.subckt vcsel_servo D DB OUT VLASER VDD VREF VSET VREGSET VL VSS params: RBASE=50 RTAIL=37.5 CC=5p CLDO=100p WBASE=60u WTAIL=84u RDUMMY=500 ATTEN=200
VVL VLASER VL 0
VDR VDD DR 0
XAB_0 ABIAS ABIAS VREF VREF pmos_3p3 w=10.0u l=2u ad=4.4p as=4.4p pd=20.88u ps=20.88u
RABIAS ABIAS VSS 100k
XBT_0 Btail ABIAS VREF VREF pmos_3p3 w=10.0u l=2u ad=4.4p as=4.4p pd=20.88u ps=20.88u
XBP1_0 Bn1 SBASE Btail VREF pmos_3p3 w=64.0u l=8u ad=28.16p as=28.16p pd=128.88u ps=128.88u
XBP1_1 Bn1 SBASE Btail VREF pmos_3p3 w=64.0u l=8u ad=28.16p as=28.16p pd=128.88u ps=128.88u
XBP2_0 Bn2 VSET Btail VREF pmos_3p3 w=64.0u l=8u ad=28.16p as=28.16p pd=128.88u ps=128.88u
XBP2_1 Bn2 VSET Btail VREF pmos_3p3 w=64.0u l=8u ad=28.16p as=28.16p pd=128.88u ps=128.88u
XBN1_0 Bn1 Bn1 VSS VSS nmos_3p3 w=32.0u l=8u ad=14.08p as=14.08p pd=64.88u ps=64.88u
XBN2_0 Bn2 Bn1 VSS VSS nmos_3p3 w=32.0u l=8u ad=14.08p as=14.08p pd=64.88u ps=64.88u
XBNS_0 BCTRL Bn2 VSS VSS nmos_3p3 w=20.0u l=1u ad=8.8p as=8.8p pd=40.88u ps=40.88u
XBPL_0 BCTRL ABIAS VREF VREF pmos_3p3 w=20.0u l=2u ad=8.8p as=8.8p pd=40.88u ps=40.88u
CBMILLER Bn2 BCTRL {CC}
XTT_0 Ttail ABIAS VREF VREF pmos_3p3 w=10.0u l=2u ad=4.4p as=4.4p pd=20.88u ps=20.88u
XTP1_0 Tn1 STAIL Ttail VREF pmos_3p3 w=64.0u l=8u ad=28.16p as=28.16p pd=128.88u ps=128.88u
XTP1_1 Tn1 STAIL Ttail VREF pmos_3p3 w=64.0u l=8u ad=28.16p as=28.16p pd=128.88u ps=128.88u
XTP2_0 Tn2 VSET Ttail VREF pmos_3p3 w=64.0u l=8u ad=28.16p as=28.16p pd=128.88u ps=128.88u
XTP2_1 Tn2 VSET Ttail VREF pmos_3p3 w=64.0u l=8u ad=28.16p as=28.16p pd=128.88u ps=128.88u
XTN1_0 Tn1 Tn1 VSS VSS nmos_3p3 w=32.0u l=8u ad=14.08p as=14.08p pd=64.88u ps=64.88u
XTN2_0 Tn2 Tn1 VSS VSS nmos_3p3 w=32.0u l=8u ad=14.08p as=14.08p pd=64.88u ps=64.88u
XTNS_0 TCTRL Tn2 VSS VSS nmos_3p3 w=20.0u l=1u ad=8.8p as=8.8p pd=40.88u ps=40.88u
XTPL_0 TCTRL ABIAS VREF VREF pmos_3p3 w=20.0u l=2u ad=8.8p as=8.8p pd=40.88u ps=40.88u
CTMILLER Tn2 TCTRL {CC}
VIBASE OUT BS 0
VITAIL VX TS 0
XBASE0 BS BCTRL SBASE VSS nmos_3p3 w={WBASE} l=1u ad={WBASE*.44u} as={WBASE*.44u} pd={2*(WBASE+.44u)} ps={2*(WBASE+.44u)}
XTAIL0 TS TCTRL STAIL VSS nmos_3p3 w={WTAIL} l=.28u ad={WTAIL*.44u} as={WTAIL*.44u} pd={2*(WTAIL+.44u)} ps={2*(WTAIL+.44u)}
RBASE SBASE VSS {RBASE}
RTAIL STAIL VSS {RTAIL}
XBASE1 BS BCTRL SBASE VSS nmos_3p3 w={WBASE} l=1u ad={WBASE*.44u} as={WBASE*.44u} pd={2*(WBASE+.44u)} ps={2*(WBASE+.44u)}
XTAIL1 TS TCTRL STAIL VSS nmos_3p3 w={WTAIL} l=.28u ad={WTAIL*.44u} as={WTAIL*.44u} pd={2*(WTAIL+.44u)} ps={2*(WTAIL+.44u)}
XSTEER_0 OUT GP VX VSS nmos_3p3 w=40.0u l=0.28u ad=17.6p as=17.6p pd=80.88u ps=80.88u
XDUMP_0 DUMMY GN VX VSS nmos_3p3 w=40.0u l=0.28u ad=17.6p as=17.6p pd=80.88u ps=80.88u
RDUMMY1 VL DUMMY {RDUMMY}
XBP1N_0 NP D VSS VSS nmos_3p3 w=4.0u l=0.28u ad=1.76p as=1.76p pd=8.88u ps=8.88u
XBP1P_0 NP D DR DR pmos_3p3 w=8.0u l=0.28u ad=3.52p as=3.52p pd=16.88u ps=16.88u
XBP2N_0 GP NP VSS VSS nmos_3p3 w=12.0u l=0.28u ad=5.28p as=5.28p pd=24.88u ps=24.88u
XBP2P_0 GP NP DR DR pmos_3p3 w=24.0u l=0.28u ad=10.56p as=10.56p pd=48.88u ps=48.88u
XBN1N_0 NN DB VSS VSS nmos_3p3 w=4.0u l=0.28u ad=1.76p as=1.76p pd=8.88u ps=8.88u
XBN1P_0 NN DB DR DR pmos_3p3 w=8.0u l=0.28u ad=3.52p as=3.52p pd=16.88u ps=16.88u
XBN2N_0 GN NN VSS VSS nmos_3p3 w=12.0u l=0.28u ad=5.28p as=5.28p pd=24.88u ps=24.88u
XBN2P_0 GN NN DR DR pmos_3p3 w=24.0u l=0.28u ad=10.56p as=10.56p pd=48.88u ps=48.88u
.ends vcsel_servo
