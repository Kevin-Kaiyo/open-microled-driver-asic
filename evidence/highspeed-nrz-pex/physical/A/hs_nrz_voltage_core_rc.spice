* Audited RC model assembly from build/highspeed-nrz-layout/r4/A/readback/hs_nrz_voltage_core.ext.
* Original Magic RC preserved in ../unmodified-full-rc/.
* R/MOS unchanged; C counted once with explicit area-weight allocation.
* Coupling remains at original logical nodes; no EM claim.
.subckt hs_nrz_voltage_core DATA OUT VDD VH VL VSS
X0 VL.t0 CTRL.t3 OUT.t1 VSS.t4 nfet_03v3 ad=1.76p pd=8.88u as=1.76p ps=8.88u w=4u l=0.28u
X1 VSS.t3 N1.t3 CTRL.t1 VSS.t2 nfet_03v3 ad=1.76p pd=8.88u as=1.76p ps=8.88u w=4u l=0.28u
X2 VSS.t1 DATA.t1 N1.t1 VSS.t0 nfet_03v3 ad=0.44p pd=2.88u as=0.44p ps=2.88u w=1u l=0.28u
X3 VH.t1 CTRL.t2 OUT.t0 VH.t0 pfet_03v3 ad=3.52p pd=16.88u as=3.52p ps=16.88u w=8u l=0.28u
X4 VDD.t1 DATA.t0 N1.t0 VDD.t0 pfet_03v3 ad=0.88p pd=4.88u as=0.88p ps=4.88u w=2u l=0.28u
X5 VDD.t3 N1.t2 CTRL.t0 VDD.t2 pfet_03v3 ad=3.52p pd=16.88u as=3.52p ps=16.88u w=8u l=0.28u
R0 VL VL.t0 13.6507
R1 OUT.n0 OUT.t0 15.0997
R2 OUT.n0 OUT.t1 14.4133
R3 OUT OUT.n0 0.0905
R4 DATA.n0 DATA.t0 70.27
R5 DATA.n0 DATA.t1 55.7659
R6 DATA DATA.n0 0.0905
R7 VH.n0 VH.t0 82.3849
R8 VH.n0 VH.t1 13.8338
R9 VH VH.n0 0.0905
R10 VDD.n2 VDD.t0 146.069
R11 VDD.n0 VDD.t2 82.6691
R12 VDD.n1 VDD.t1 15.1421
R13 VDD.n0 VDD.t3 14.118
R14 VDD.n1 VDD.n0 2.048
R15 VDD.n2 VDD.n1 0.653
R16 VDD VDD.n2 0.0905
R17 VSS.n4 VSS.n1 6046.37
R18 VSS.t2 VSS.t4 2609.12
R19 VSS.n5 VSS.t2 2149.07
R20 VSS.n6 VSS.t0 470.868
R21 VSS.t0 VSS.n5 346.983
R22 VSS.t2 VSS.n4 252.357
R23 VSS.n2 VSS.t4 200.181
R24 VSS.n5 VSS.n1 122.846
R25 VSS.n6 VSS.n1 47.3183
R26 VSS.n0 VSS.t1 16.8674
R27 VSS.n7 VSS.n6 13.4534
R28 VSS.n2 VSS.t3 13.2764
R29 VSS.n4 VSS.n3 13.1405
R30 VSS.n3 VSS.n0 2.048
R31 VSS.n7 VSS.n0 0.653
R32 VSS.n3 VSS.n2 0.653
R33 VSS VSS.n7 0.0905
R34 CTRL.n0 CTRL.t2 147.206
R35 CTRL.n0 CTRL.t3 93.2388
R36 CTRL.n4 CTRL.n3 12.2985
R37 CTRL.n1 CTRL.t0 12.0444
R38 CTRL.n1 CTRL.n0 1.4405
R39 CTRL.n4 CTRL.n1 1.3505
R40 CTRL.n3 CTRL.t1 0.41
R41 CTRL.n3 CTRL.n2 0.284
R42 CTRL CTRL.n4 0.068
R43 N1.n0 N1.t2 147.489
R44 N1.n0 N1.t3 93.5231
R45 N1.n4 N1.n3 14.9452
R46 N1.n1 N1.t0 14.0052
R47 N1.n3 N1.t1 1.6385
R48 N1.n1 N1.n0 1.4405
R49 N1.n4 N1.n1 1.3505
R50 N1.n3 N1.n2 1.1345
R51 N1 N1.n4 0.068
C0 CTRL VSS 1.2746160235927899e-17
C1 CTRL.n0 VSS 1.4414324105021711e-15
C2 CTRL.n1 VSS 4.3603234009631566e-16
C3 CTRL.n2 VSS 3.2775898596481725e-17
C4 CTRL.n3 VSS 3.4075479233275463e-16
C5 CTRL.n4 VSS 3.2248394289902482e-16
C6 CTRL.t0 VSS 6.6239744806334119e-16
C7 CTRL.t1 VSS 4.7342953363566108e-17
C8 CTRL.t2 VSS 2.3951719687288749e-16
C9 CTRL.t3 VSS 1.6513685703752924e-16
C10 DATA VSS 1.4652207646159826e-17
C11 DATA.n0 VSS 2.1130598912938014e-15
C12 DATA.t0 VSS 2.5236104457969953e-16
C13 DATA.t1 VSS 2.2689685648033893e-16
C14 N1 VSS 1.4765076860154796e-17
C15 N1.n0 VSS 1.7585616997420427e-15
C16 N1.n1 VSS 5.56911339111253e-16
C17 N1.n2 VSS 9.4918491667039413e-18
C18 N1.n3 VSS 2.3933166326546101e-16
C19 N1.n4 VSS 4.3467435892165029e-16
C20 N1.t0 VSS 3.3962471199780491e-16
C21 N1.t1 VSS 1.3710442555319597e-17
C22 N1.t2 VSS 2.807171849848141e-16
C23 N1.t3 VSS 1.9540167339479585e-16
C24 OUT VSS 7.8827453580364072e-18
C25 OUT.n0 VSS 6.426748931307756e-16
C26 OUT.t0 VSS 5.9609129288060503e-16
C27 OUT.t1 VSS 3.7993106863058307e-16
C28 VDD VSS 1.1324520128791844e-17
C29 VDD.n0 VSS 3.0363722082492637e-15
C30 VDD.n1 VSS 5.859614444188724e-16
C31 VDD.n2 VSS 1.7478301531423592e-15
C32 VDD.t0 VSS 7.2480628605529968e-16
C33 VDD.t1 VSS 3.808493004676321e-16
C34 VDD.t2 VSS 2.2253497329809009e-15
C35 VDD.t3 VSS 8.1068635455688098e-16
C36 VH VSS 1.0333261268184929e-17
C37 VH.n0 VSS 2.5717967907885023e-15
C38 VH.t0 VSS 2.020862682117506e-15
C39 VH.t1 VSS 7.1983726582580738e-16
C40 VL VSS 2.6313057412991092e-16
C41 VL.t0 VSS 3.8602042587008906e-16
C42 CTRL OUT 4.2240800000000006e-16
C43 N1 VL 7.8807500000000004e-19
C44 VDD CTRL 1.6369700000000001e-15
C45 CTRL VL 1.9477200000000002e-16
C46 VDD OUT 1.7550800000000001e-17
C47 DATA N1 4.0813000000000004e-16
C48 VH CTRL 6.7901300000000011e-16
C49 OUT VL 7.1160699999999999e-16
C50 VDD VL 5.89101e-19
C51 VH OUT 1.8236100000000001e-15
C52 DATA CTRL 8.6813300000000009e-18
C53 VH VL 1.1639200000000001e-16
C54 N1 CTRL 7.0472500000000003e-16
C55 VDD DATA 6.1210700000000005e-16
C56 N1 OUT 8.8674700000000008e-18
C57 VDD N1 1.6143500000000001e-15
.ends hs_nrz_voltage_core
