* NGSPICE file created from hs_nrz_voltage_core.ext - technology: gf180mcuD

.subckt hs_nrz_voltage_core DATA OUT VDD VH VL VSS
X0 VL.t0 CTRL.t3 OUT.t1 VSS.t4 nfet_03v3 ad=1.76p pd=8.88u as=1.76p ps=8.88u w=4u l=0.28u
X1 VSS.t3 N1.t3 CTRL.t1 VSS.t2 nfet_03v3 ad=1.76p pd=8.88u as=1.76p ps=8.88u w=4u l=0.28u
X2 VSS.t1 DATA.t1 N1.t1 VSS.t0 nfet_03v3 ad=0.44p pd=2.88u as=0.44p ps=2.88u w=1u l=0.28u
X3 VH.t1 CTRL.t2 OUT.t0 VH.t0 pfet_03v3 ad=3.52p pd=16.88u as=3.52p ps=16.88u w=8u l=0.28u
X4 VDD.t1 DATA.t0 N1.t0 VDD.t0 pfet_03v3 ad=0.88p pd=4.88u as=0.88p ps=4.88u w=2u l=0.28u
X5 VDD.t3 N1.t2 CTRL.t0 VDD.t2 pfet_03v3 ad=3.52p pd=16.88u as=3.52p ps=16.88u w=8u l=0.28u
R0 VL VL.t0 13.6507
R1 OUT.n0 OUT.t0 15.0997
R2 OUT.n0 OUT.t1 14.4133
R3 OUT OUT.n0 0.0905
R4 DATA.n0 DATA.t0 70.27
R5 DATA.n0 DATA.t1 55.7659
R6 DATA DATA.n0 0.0905
R7 VH.n0 VH.t0 82.3849
R8 VH.n0 VH.t1 13.8338
R9 VH VH.n0 0.0905
R10 VDD.n2 VDD.t0 146.069
R11 VDD.n0 VDD.t2 82.6691
R12 VDD.n1 VDD.t1 15.1421
R13 VDD.n0 VDD.t3 14.118
R14 VDD.n1 VDD.n0 2.048
R15 VDD.n2 VDD.n1 0.653
R16 VDD VDD.n2 0.0905
R17 VSS.n4 VSS.n1 6046.37
R18 VSS.t2 VSS.t4 2609.12
R19 VSS.n5 VSS.t2 2149.07
R20 VSS.n6 VSS.t0 470.868
R21 VSS.t0 VSS.n5 346.983
R22 VSS.t2 VSS.n4 252.357
R23 VSS.n2 VSS.t4 200.181
R24 VSS.n5 VSS.n1 122.846
R25 VSS.n6 VSS.n1 47.3183
R26 VSS.n0 VSS.t1 16.8674
R27 VSS.n7 VSS.n6 13.4534
R28 VSS.n2 VSS.t3 13.2764
R29 VSS.n4 VSS.n3 13.1405
R30 VSS.n3 VSS.n0 2.048
R31 VSS.n7 VSS.n0 0.653
R32 VSS.n3 VSS.n2 0.653
R33 VSS VSS.n7 0.0905
R34 CTRL.n0 CTRL.t2 147.206
R35 CTRL.n0 CTRL.t3 93.2388
R36 CTRL.n4 CTRL.n3 12.2985
R37 CTRL.n1 CTRL.t0 12.0444
R38 CTRL.n1 CTRL.n0 1.4405
R39 CTRL.n4 CTRL.n1 1.3505
R40 CTRL.n3 CTRL.t1 0.41
R41 CTRL.n3 CTRL.n2 0.284
R42 CTRL CTRL.n4 0.068
R43 N1.n0 N1.t2 147.489
R44 N1.n0 N1.t3 93.5231
R45 N1.n4 N1.n3 14.9452
R46 N1.n1 N1.t0 14.0052
R47 N1.n3 N1.t1 1.6385
R48 N1.n1 N1.n0 1.4405
R49 N1.n4 N1.n1 1.3505
R50 N1.n3 N1.n2 1.1345
R51 N1 N1.n4 0.068
C0 VDD VL 0
C1 VH OUT 1.82361f
C2 VDD OUT 0.01755f
C3 N1 CTRL 0.70472f
C4 CTRL VL 0.19477f
C5 VDD DATA 0.61211f
C6 CTRL OUT 0.42241f
C7 N1 VL 0
C8 CTRL DATA 0.00868f
C9 N1 OUT 0.00887f
C10 OUT VL 0.71161f
C11 N1 DATA 0.40813f
C12 CTRL VH 0.67901f
C13 CTRL VDD 1.63697f
C14 VH VL 0.11639f
C15 N1 VDD 1.61435f
C16 VL VSS 1.06429f
 ; **nodeattr VL : res:drive
C17 OUT VSS 1.64104f
 ; **nodeattr OUT : res:drive
C18 DATA VSS 2.61275f
 ; **nodeattr DATA : res:drive
C19 VH VSS 5.32791f
 ; **nodeattr VH : res:drive
C20 VDD VSS 9.5278f
 ; **nodeattr VDD : res:drive
C21 CTRL VSS 3.71318f
 ; **nodeattr CTRL : res:drive
C22 N1 VSS 3.8537f
 ; **nodeattr N1 : res:drive
C23 N1.n0 VSS 1.25233f
C24 N1.t0 VSS 0.29166f
C25 N1.n1 VSS 0.3966f
C26 N1.t1 VSS 0.05454f
C27 N1.n2 VSS 0.00676f
C28 N1.n3 VSS 0.17044f
C29 N1.n4 VSS 0.30955f
C30 CTRL.n0 VSS 1.42038f
C31 CTRL.t0 VSS 0.75268f
C32 CTRL.n1 VSS 0.42966f
C33 CTRL.t1 VSS 0.11623f
C34 CTRL.n2 VSS 0.0323f
C35 CTRL.n3 VSS 0.33578f
C36 CTRL.n4 VSS 0.31777f
C37 VSS.t1 VSS 0.04478f
C38 VSS.t3 VSS 0.06958f
C39 VDD.t3 VSS 0.43038f
C40 VDD.t2 VSS 0.90703f
C41 VDD.n0 VSS 1.2376f
C42 VDD.t1 VSS 0.20503f
C43 VDD.n1 VSS 0.23883f
C44 VDD.t0 VSS 0.29542f
C45 VDD.n2 VSS 0.7124f
C46 VH.t1 VSS 0.47219f
C47 VH.t0 VSS 0.99433f
C48 VH.n0 VSS 1.26541f
C49 DATA.n0 VSS 0.83398f
C50 OUT.t0 VSS 1.21157f
C51 OUT.t1 VSS 0.77837f
C52 OUT.n0 VSS 1.17902f
C53 VL.t0 VSS 0.69038f
.ends
