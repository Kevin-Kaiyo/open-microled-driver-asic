* NGSPICE file created from hs_nrz_voltage_core.ext - technology: gf180mcuD

X0 VL CTRL OUT VSS nfet_03v3 ad=1.76p pd=8.88u as=1.76p ps=8.88u w=4u l=0.28u
X1 VSS N1 CTRL VSS nfet_03v3 ad=1.76p pd=8.88u as=1.76p ps=8.88u w=4u l=0.28u
X2 VSS DATA N1 VSS nfet_03v3 ad=0.44p pd=2.88u as=0.44p ps=2.88u w=1u l=0.28u
X3 VH CTRL OUT VH pfet_03v3 ad=3.52p pd=16.88u as=3.52p ps=16.88u w=8u l=0.28u
X4 VDD DATA N1 VDD pfet_03v3 ad=0.88p pd=4.88u as=0.88p ps=4.88u w=2u l=0.28u
X5 VDD N1 CTRL VDD pfet_03v3 ad=3.52p pd=16.88u as=3.52p ps=16.88u w=8u l=0.28u
C0 N1 CTRL 0.70472f
C1 CTRL VL 0.19477f
C2 VDD DATA 0.61211f
C3 CTRL OUT 0.42241f
C4 N1 VL 0
C5 CTRL DATA 0.00868f
C6 N1 OUT 0.00887f
C7 OUT VL 0.71161f
C8 N1 DATA 0.40813f
C9 CTRL VH 0.67901f
C10 CTRL VDD 1.63697f
C11 VH VL 0.11639f
C12 N1 VDD 1.61435f
C13 VDD VL 0
C14 VH OUT 1.82361f
C15 VDD OUT 0.01755f
C16 VL VSS 0.64915f
C17 OUT VSS 1.62658f
C18 DATA VSS 2.60697f
C19 VH VSS 5.32283f
C20 VDD VSS 9.52318f
C21 CTRL VSS 3.70062f ; **FLOATING
C22 N1 VSS 3.84319f ; **FLOATING
