* C-placement sensitivity control: same full R/MOS, all .ext C at original nets.
.subckt hs_nrz_voltage_core DATA OUT VDD VH VL VSS
X0 VL.t0 CTRL.t3 OUT.t1 VSS.t4 nfet_03v3 ad=1.76p pd=8.88u as=1.76p ps=8.88u w=4u l=0.28u
X1 VSS.t3 N1.t3 CTRL.t1 VSS.t2 nfet_03v3 ad=1.76p pd=8.88u as=1.76p ps=8.88u w=4u l=0.28u
X2 VSS.t1 DATA.t1 N1.t1 VSS.t0 nfet_03v3 ad=0.44p pd=2.88u as=0.44p ps=2.88u w=1u l=0.28u
X3 VH.t1 CTRL.t2 OUT.t0 VH.t0 pfet_03v3 ad=3.52p pd=16.88u as=3.52p ps=16.88u w=8u l=0.28u
X4 VDD.t1 DATA.t0 N1.t0 VDD.t0 pfet_03v3 ad=0.88p pd=4.88u as=0.88p ps=4.88u w=2u l=0.28u
X5 VDD.t3 N1.t2 CTRL.t0 VDD.t2 pfet_03v3 ad=3.52p pd=16.88u as=3.52p ps=16.88u w=8u l=0.28u
R0 VL VL.t0 13.6507
R1 OUT.n0 OUT.t0 15.0997
R2 OUT.n0 OUT.t1 14.4133
R3 OUT OUT.n0 0.0905
R4 DATA.n0 DATA.t0 70.27
R5 DATA.n0 DATA.t1 55.7659
R6 DATA DATA.n0 0.0905
R7 VH.n0 VH.t0 82.3849
R8 VH.n0 VH.t1 13.8338
R9 VH VH.n0 0.0905
R10 VDD.n2 VDD.t0 146.069
R11 VDD.n0 VDD.t2 82.6691
R12 VDD.n1 VDD.t1 15.1421
R13 VDD.n0 VDD.t3 14.118
R14 VDD.n1 VDD.n0 2.048
R15 VDD.n2 VDD.n1 0.653
R16 VDD VDD.n2 0.0905
R17 VSS.n4 VSS.n1 6046.37
R18 VSS.t2 VSS.t4 2609.12
R19 VSS.n5 VSS.t2 2149.07
R20 VSS.n6 VSS.t0 470.868
R21 VSS.t0 VSS.n5 346.983
R22 VSS.t2 VSS.n4 252.357
R23 VSS.n2 VSS.t4 200.181
R24 VSS.n5 VSS.n1 122.846
R25 VSS.n6 VSS.n1 47.3183
R26 VSS.n0 VSS.t1 16.8674
R27 VSS.n7 VSS.n6 13.4534
R28 VSS.n2 VSS.t3 13.2764
R29 VSS.n4 VSS.n3 13.1405
R30 VSS.n3 VSS.n0 2.048
R31 VSS.n7 VSS.n0 0.653
R32 VSS.n3 VSS.n2 0.653
R33 VSS VSS.n7 0.0905
R34 CTRL.n0 CTRL.t2 147.206
R35 CTRL.n0 CTRL.t3 93.2388
R36 CTRL.n4 CTRL.n3 12.2985
R37 CTRL.n1 CTRL.t0 12.0444
R38 CTRL.n1 CTRL.n0 1.4405
R39 CTRL.n4 CTRL.n1 1.3505
R40 CTRL.n3 CTRL.t1 0.41
R41 CTRL.n3 CTRL.n2 0.284
R42 CTRL CTRL.n4 0.068
R43 N1.n0 N1.t2 147.489
R44 N1.n0 N1.t3 93.5231
R45 N1.n4 N1.n3 14.9452
R46 N1.n1 N1.t0 14.0052
R47 N1.n3 N1.t1 1.6385
R48 N1.n1 N1.n0 1.4405
R49 N1.n4 N1.n1 1.3505
R50 N1.n3 N1.n2 1.1345
R51 N1 N1.n4 0.068
C0 CTRL VSS 3.7006199999999998e-15
C1 DATA VSS 2.6069699999999998e-15
C2 N1 VSS 3.84319e-15
C3 OUT VSS 1.6265800000000001e-15
C4 VDD VSS 9.5231800000000003e-15
C5 VH VSS 5.3228300000000005e-15
C6 VL VSS 6.4915100000000002e-16
C7 CTRL OUT 4.2240800000000006e-16
C8 N1 VL 7.8807500000000004e-19
C9 VDD CTRL 1.6369700000000001e-15
C10 CTRL VL 1.9477200000000002e-16
C11 VDD OUT 1.7550800000000001e-17
C12 DATA N1 4.0813000000000004e-16
C13 VH CTRL 6.7901300000000011e-16
C14 OUT VL 7.1160699999999999e-16
C15 VDD VL 5.89101e-19
C16 VH OUT 1.8236100000000001e-15
C17 DATA CTRL 8.6813300000000009e-18
C18 VH VL 1.1639200000000001e-16
C19 N1 CTRL 7.0472500000000003e-16
C20 VDD DATA 6.1210700000000005e-16
C21 N1 OUT 8.8674700000000008e-18
C22 VDD N1 1.6143500000000001e-15
.ends hs_nrz_voltage_core
