* Explicit control derived from full raw RC; original RC retained.
.subckt hs_nrz_voltage_core DATA OUT VDD VH VL VSS
X0 VL CTRL OUT VSS nfet_03v3 ad=1.76p pd=8.88u as=1.76p ps=8.88u w=4u l=0.28u
X1 VSS N1 CTRL VSS nfet_03v3 ad=1.76p pd=8.88u as=1.76p ps=8.88u w=4u l=0.28u
X2 VSS DATA N1 VSS nfet_03v3 ad=0.44p pd=2.88u as=0.44p ps=2.88u w=1u l=0.28u
X3 VH CTRL OUT VH pfet_03v3 ad=3.52p pd=16.88u as=3.52p ps=16.88u w=8u l=0.28u
X4 VDD DATA N1 VDD pfet_03v3 ad=0.88p pd=4.88u as=0.88p ps=4.88u w=2u l=0.28u
X5 VDD N1 CTRL VDD pfet_03v3 ad=3.52p pd=16.88u as=3.52p ps=16.88u w=8u l=0.28u
C0 CTRL VSS 1.27461602359e-17
C1 CTRL VSS 1.4414324105e-15
C2 CTRL VSS 4.36032340096e-16
C3 CTRL VSS 3.27758985965e-17
C4 CTRL VSS 3.40754792333e-16
C5 CTRL VSS 3.22483942899e-16
C6 CTRL VSS 6.62397448063e-16
C7 CTRL VSS 4.73429533636e-17
C8 CTRL VSS 2.39517196873e-16
C9 CTRL VSS 1.65136857038e-16
C10 DATA VSS 1.46522076462e-17
C11 DATA VSS 2.11305989129e-15
C12 DATA VSS 2.5236104458e-16
C13 DATA VSS 2.2689685648e-16
C14 N1 VSS 1.47650768602e-17
C15 N1 VSS 1.75856169974e-15
C16 N1 VSS 5.56911339111e-16
C17 N1 VSS 9.4918491667e-18
C18 N1 VSS 2.39331663265e-16
C19 N1 VSS 4.34674358922e-16
C20 N1 VSS 3.39624711998e-16
C21 N1 VSS 1.37104425553e-17
C22 N1 VSS 2.80717184985e-16
C23 N1 VSS 1.95401673395e-16
C24 OUT VSS 7.88274535804e-18
C25 OUT VSS 6.42674893131e-16
C26 OUT VSS 5.96091292881e-16
C27 OUT VSS 3.79931068631e-16
C28 VDD VSS 1.13245201288e-17
C29 VDD VSS 3.03637220825e-15
C30 VDD VSS 5.85961444419e-16
C31 VDD VSS 1.74783015314e-15
C32 VDD VSS 7.24806286055e-16
C33 VDD VSS 3.80849300468e-16
C34 VDD VSS 2.22534973298e-15
C35 VDD VSS 8.10686354557e-16
C36 VH VSS 1.03332612682e-17
C37 VH VSS 2.57179679079e-15
C38 VH VSS 2.02086268212e-15
C39 VH VSS 7.19837265826e-16
C40 VL VSS 2.6313057413e-16
C41 VL VSS 3.8602042587e-16
C42 CTRL OUT 4.22408e-16
C43 N1 VL 7.88075e-19
C44 VDD CTRL 1.63697e-15
C45 CTRL VL 1.94772e-16
C46 VDD OUT 1.75508e-17
C47 DATA N1 4.0813e-16
C48 VH CTRL 6.79013e-16
C49 OUT VL 7.11607e-16
C50 VDD VL 5.89101e-19
C51 VH OUT 1.82361e-15
C52 DATA CTRL 8.68133e-18
C53 VH VL 1.16392e-16
C54 N1 CTRL 7.04725e-16
C55 VDD DATA 6.12107e-16
C56 N1 OUT 8.86747e-18
C57 VDD N1 1.61435e-15
.ends hs_nrz_voltage_core
