* Audited RC model assembly from build/highspeed-nrz-layout/r4/B/readback/hs_nrz_steering_core.ext.
* Original Magic RC preserved in ../unmodified-full-rc/.
* R/MOS unchanged; C counted once with explicit area-weight allocation.
* Coupling remains at original logical nodes; no EM claim.
.subckt hs_nrz_steering_core DATA OUT VDD VSS BIAS DUMMY
X0 VDD.t3 GB.t3 GP.t1 VDD.t2 pfet_03v3 ad=0.88p pd=4.88u as=0.88p ps=4.88u w=2u l=0.28u
X1 VX.t2 GP.t2 OUT.t1 VSS.t11 nfet_03v3 ad=0.44p pd=2.88u as=0.44p ps=2.88u w=1u l=0.28u
X2 VSS.t10 GB.t4 GP.t0 VSS.t9 nfet_03v3 ad=0.44p pd=2.88u as=0.44p ps=2.88u w=1u l=0.28u
X3 VSS.t7 DATA.t1 GB.t1 VSS.t6 nfet_03v3 ad=0.44p pd=2.88u as=0.44p ps=2.88u w=1u l=0.28u
X4 VX.t1 GB.t2 DUMMY.t0 VSS.t8 nfet_03v3 ad=0.44p pd=2.88u as=0.44p ps=2.88u w=1u l=0.28u
X5 VSS.t5 BIAS.t2 OUT.t0 VSS.t4 nfet_03v3 ad=0.88p pd=4.88u as=0.88p ps=4.88u w=2u l=1u
X6 VDD.t1 DATA.t0 GB.t0 VDD.t0 pfet_03v3 ad=0.88p pd=4.88u as=0.88p ps=4.88u w=2u l=0.28u
X7 VSS.t3 BIAS.t3 VX.t0 VSS.t2 nfet_03v3 ad=2.5344p pd=12.4u as=2.5344p ps=12.4u w=5.76u l=1u
X8 VSS.t1 BIAS.t0 BIAS.t1 VSS.t0 nfet_03v3 ad=0.88p pd=4.88u as=0.88p ps=4.88u w=2u l=1u
R0 BIAS.n2 BIAS.t3 50.8382
R1 BIAS.n0 BIAS.t0 36.8399
R2 BIAS.n1 BIAS.t2 36.6689
R3 BIAS.n0 BIAS.t1 14.7577
R4 BIAS.n2 BIAS.n1 1.3505
R5 BIAS.n1 BIAS.n0 1.1795
R6 BIAS BIAS.n2 0.0905
R7 DUMMY DUMMY.t0 16.9574
R8 OUT.n0 OUT.t0 19.5793
R9 OUT.n0 OUT.t1 18.0043
R10 OUT OUT.n0 0.0905
R11 DATA.n0 DATA.t0 70.27
R12 DATA.n0 DATA.t1 55.7659
R13 DATA DATA.n0 0.0905
R14 VDD.n2 VDD.t0 146.069
R15 VDD.n0 VDD.t2 146.069
R16 VDD.n0 VDD.t3 15.7946
R17 VDD.n1 VDD.t1 15.1421
R18 VDD.n1 VDD.n0 2.048
R19 VDD.n2 VDD.n1 0.653
R20 VDD VDD.n2 0.0905
R21 VSS.n26 VSS.n1 8369.71
R22 VSS.n27 VSS.t9 2149.07
R23 VSS.n20 VSS.n2 1581.95
R24 VSS.n28 VSS.t6 552.832
R25 VSS.t9 VSS.n26 551.792
R26 VSS.n19 VSS.n18 531.692
R27 VSS.n16 VSS.n15 481.586
R28 VSS.n25 VSS.n2 472.067
R29 VSS.n8 VSS.n7 431.798
R30 VSS.n9 VSS.n4 431.478
R31 VSS.t6 VSS.n27 407.517
R32 VSS.t4 VSS.n8 201.821
R33 VSS.n15 VSS.t2 201.821
R34 VSS.n9 VSS.t4 201.821
R35 VSS.n4 VSS.t2 201.821
R36 VSS.t11 VSS.n19 151.714
R37 VSS.n18 VSS.t8 151.714
R38 VSS.n16 VSS.t8 151.714
R39 VSS.n20 VSS.t11 151.714
R40 VSS.n27 VSS.n1 144.276
R41 VSS.n7 VSS.t0 114.492
R42 VSS.n14 VSS.n4 99.9027
R43 VSS.t9 VSS.n2 91.4677
R44 VSS.n10 VSS.n8 63.7434
R45 VSS.n28 VSS.n1 47.3183
R46 VSS.n17 VSS.n16 47.3183
R47 VSS.n21 VSS.n19 47.3183
R48 VSS.n23 VSS.t10 17.4359
R49 VSS.n0 VSS.t7 17.4359
R50 VSS.n6 VSS.t1 15.7754
R51 VSS.n5 VSS.t5 15.0419
R52 VSS.n7 VSS.n6 14.0613
R53 VSS.n29 VSS.n28 14.0218
R54 VSS.n17 VSS.n3 14.0218
R55 VSS.n22 VSS.n21 14.0218
R56 VSS.n25 VSS.n24 14.0218
R57 VSS.n11 VSS.n10 13.6394
R58 VSS.n12 VSS.t3 13.4572
R59 VSS.n14 VSS.n13 13.2432
R60 VSS.n24 VSS.n0 2.048
R61 VSS.n23 VSS.n22 2.048
R62 VSS.n22 VSS.n3 1.3505
R63 VSS.n13 VSS.n3 1.3505
R64 VSS.n21 VSS.n20 1.0405
R65 VSS.n26 VSS.n25 1.0405
R66 VSS.n18 VSS.n17 1.0405
R67 VSS.n10 VSS.n9 0.743357
R68 VSS.n11 VSS.n5 0.734
R69 VSS.n13 VSS.n12 0.734
R70 VSS.n24 VSS.n23 0.653
R71 VSS.n29 VSS.n0 0.653
R72 VSS.n6 VSS.n5 0.617
R73 VSS.n12 VSS.n11 0.617
R74 VSS.n15 VSS.n14 0.347167
R75 VSS VSS.n29 0.0905
R76 VX.n0 VX.t1 16.0148
R77 VX.n1 VX.t2 16.0148
R78 VX.n0 VX.t0 13.1252
R79 VX.n1 VX.n0 1.3505
R80 VX VX.n1 0.068
R81 GP.n0 GP.t2 55.2164
R82 GP.n3 GP.n2 14.661
R83 GP.n0 GP.t1 13.721
R84 GP.n2 GP.t0 1.6385
R85 GP.n3 GP.n0 1.3505
R86 GP.n2 GP.n1 1.1345
R87 GP GP.n3 0.068
R88 GB.n0 GB.t3 67.2148
R89 GB.n0 GB.t2 56.7606
R90 GB.n1 GB.t4 54.0607
R91 GB.n5 GB.n4 14.9452
R92 GB.n2 GB.t0 14.0052
R93 GB.n4 GB.t1 1.6385
R94 GB.n2 GB.n1 1.4405
R95 GB.n5 GB.n2 1.3505
R96 GB.n1 GB.n0 1.3505
R97 GB.n4 GB.n3 1.1345
R98 GB GB.n5 0.068
C0 BIAS VSS 1.5302623938722793e-17
C1 BIAS.n0 VSS 1.3359040441767979e-15
C2 BIAS.n1 VSS 1.0026332863074548e-15
C3 BIAS.n2 VSS 1.0825718431386194e-15
C4 BIAS.t0 VSS 6.0409784069498595e-16
C5 BIAS.t1 VSS 4.5852416010965989e-16
C6 BIAS.t2 VSS 6.0056664298032018e-16
C7 BIAS.t3 VSS 9.677695586534401e-16
C8 DATA VSS 1.4798665220595891e-17
C9 DATA.n0 VSS 2.1341827174012348e-15
C10 DATA.t0 VSS 2.548837717021502e-16
C11 DATA.t1 VSS 2.291648456760199e-16
C12 DUMMY VSS 3.9512940335194812e-16
C13 DUMMY.t0 VSS 2.5804459664805188e-16
C14 GB VSS 1.5162213762174372e-17
C15 GB.n0 VSS 1.7242686452131555e-15
C16 GB.n1 VSS 7.9438956714200275e-16
C17 GB.n2 VSS 5.7188794453490761e-16
C18 GB.n3 VSS 9.747097559305868e-18
C19 GB.n4 VSS 2.4576725866316431e-16
C20 GB.n5 VSS 4.4636344160171008e-16
C21 GB.t0 VSS 3.4875853897972634e-16
C22 GB.t1 VSS 1.4079078915743234e-17
C23 GB.t2 VSS 1.9537721403012373e-16
C24 GB.t3 VSS 1.6826815125854995e-16
C25 GB.t4 VSS 1.5697084833943691e-16
C26 GP VSS 1.5230736106536514e-17
C27 GP.n0 VSS 1.1762644922659855e-15
C28 GP.n1 VSS 9.7911908012146945e-18
C29 GP.n2 VSS 2.2624990073187265e-16
C30 GP.n3 VSS 4.1940323219122345e-16
C31 GP.t0 VSS 1.414285942619613e-17
C32 GP.t1 VSS 3.2843074461922799e-16
C33 GP.t2 VSS 1.6776684385774338e-16
C34 OUT VSS 1.6668150030845878e-17
C35 OUT.n0 VSS 1.9892501713111469e-15
C36 OUT.t0 VSS 8.0446320093398526e-16
C37 OUT.t1 VSS 4.3818847772402255e-16
C38 VDD VSS 1.2108674997310185e-17
C39 VDD.n0 VSS 2.4883613707680178e-15
C40 VDD.n1 VSS 6.2653641037617905e-16
C41 VDD.n2 VSS 1.868851997900214e-15
C42 VDD.t0 VSS 7.7499484812125519e-16
C43 VDD.t1 VSS 4.0722101349640001e-16
C44 VDD.t2 VSS 7.7499484812125519e-16
C45 VDD.t3 VSS 4.2635083621936923e-16
C46 VX VSS 1.6250393282048887e-17
C47 VX.n0 VSS 8.9507395330380848e-16
C48 VX.n1 VSS 4.3991142988750362e-16
C49 VX.t0 VSS 6.7121968174099171e-16
C50 VX.t1 VSS 2.2157227089282363e-16
C51 VX.t2 VSS 2.2157227089282363e-16
C52 BIAS VX 2.54311e-16
C53 GB DUMMY 1.6528000000000002e-16
C54 GP VX 1.3578899999999999e-16
C55 VDD GP 9.1993800000000008e-16
C56 DATA GB 4.1595600000000004e-16
C57 BIAS DUMMY 8.4883400000000002e-19
C58 OUT VX 3.9868200000000004e-16
C59 GP DUMMY 7.0441500000000011e-18
C60 VDD OUT 5.9964899999999999e-18
C61 DATA GP 7.2814600000000004e-18
C62 BIAS GB 8.6539100000000011e-17
C63 OUT DUMMY 2.6675400000000002e-19
C64 VDD VX 2.3310800000000003e-19
C65 GB GP 8.3362400000000009e-16
C66 VX DUMMY 4.4542400000000002e-16
C67 GB OUT 6.4230199999999999e-17
C68 VDD DATA 6.0485400000000013e-16
C69 BIAS OUT 2.1191100000000002e-16
C70 GP OUT 1.3469500000000001e-16
C71 GB VX 2.4578600000000003e-16
C72 VDD GB 1.5511600000000001e-15
.ends hs_nrz_steering_core
