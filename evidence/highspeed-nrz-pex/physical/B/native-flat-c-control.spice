* NGSPICE file created from hs_nrz_steering_core.ext - technology: gf180mcuD

X0 VDD GB GP VDD pfet_03v3 ad=0.88p pd=4.88u as=0.88p ps=4.88u w=2u l=0.28u
X1 VX GP OUT VSS nfet_03v3 ad=0.44p pd=2.88u as=0.44p ps=2.88u w=1u l=0.28u
X2 VSS GB GP VSS nfet_03v3 ad=0.44p pd=2.88u as=0.44p ps=2.88u w=1u l=0.28u
X3 VSS DATA GB VSS nfet_03v3 ad=0.44p pd=2.88u as=0.44p ps=2.88u w=1u l=0.28u
X4 VX GB DUMMY VSS nfet_03v3 ad=0.44p pd=2.88u as=0.44p ps=2.88u w=1u l=0.28u
X5 VSS BIAS OUT VSS nfet_03v3 ad=0.88p pd=4.88u as=0.88p ps=4.88u w=2u l=1u
X6 VDD DATA GB VDD pfet_03v3 ad=0.88p pd=4.88u as=0.88p ps=4.88u w=2u l=0.28u
X7 VSS BIAS VX VSS nfet_03v3 ad=2.5344p pd=12.4u as=2.5344p ps=12.4u w=5.76u l=1u
X8 VSS BIAS BIAS VSS nfet_03v3 ad=0.88p pd=4.88u as=0.88p ps=4.88u w=2u l=1u
C0 DUMMY BIAS 0
C1 GB DUMMY 0.16528f
C2 GP OUT 0.1347f
C3 OUT BIAS 0.21191f
C4 GP DATA 0.00728f
C5 VX VDD 0
C6 GB OUT 0.06423f
C7 OUT DUMMY 0
C8 GP VDD 0.91994f
C9 GB DATA 0.41596f
C10 GB VDD 1.55116f
C11 GP VX 0.13579f
C12 VX BIAS 0.25431f
C13 VDD OUT 0.006f
C14 GB VX 0.24579f
C15 VX DUMMY 0.44542f
C16 VDD DATA 0.60485f
C17 GB GP 0.83362f
C18 VX OUT 0.39868f
C19 GP DUMMY 0.00704f
C20 GB BIAS 0.08654f
C21 BIAS VSS 6.06737f
C22 DUMMY VSS 0.65317f
C23 OUT VSS 3.24857f
C24 DATA VSS 2.63303f
C25 VDD VSS 7.37942f
C26 VX VSS 2.4656f ; **FLOATING
C27 GP VSS 2.35728f ; **FLOATING
C28 GB VSS 4.69104f ; **FLOATING
