* Explicit control derived from full raw RC; original RC retained.
.subckt hs_nrz_steering_core DATA OUT VDD VSS BIAS DUMMY
X0 VDD GB GP VDD pfet_03v3 ad=0.88p pd=4.88u as=0.88p ps=4.88u w=2u l=0.28u
X1 VX GP OUT VSS nfet_03v3 ad=0.44p pd=2.88u as=0.44p ps=2.88u w=1u l=0.28u
X2 VSS GB GP VSS nfet_03v3 ad=0.44p pd=2.88u as=0.44p ps=2.88u w=1u l=0.28u
X3 VSS DATA GB VSS nfet_03v3 ad=0.44p pd=2.88u as=0.44p ps=2.88u w=1u l=0.28u
X4 VX GB DUMMY VSS nfet_03v3 ad=0.44p pd=2.88u as=0.44p ps=2.88u w=1u l=0.28u
X5 VSS BIAS OUT VSS nfet_03v3 ad=0.88p pd=4.88u as=0.88p ps=4.88u w=2u l=1u
X6 VDD DATA GB VDD pfet_03v3 ad=0.88p pd=4.88u as=0.88p ps=4.88u w=2u l=0.28u
X7 VSS BIAS VX VSS nfet_03v3 ad=2.5344p pd=12.4u as=2.5344p ps=12.4u w=5.76u l=1u
X8 VSS BIAS BIAS VSS nfet_03v3 ad=0.88p pd=4.88u as=0.88p ps=4.88u w=2u l=1u
C0 BIAS VSS 1.53026239387e-17
C1 BIAS VSS 1.33590404418e-15
C2 BIAS VSS 1.00263328631e-15
C3 BIAS VSS 1.08257184314e-15
C4 BIAS VSS 6.04097840695e-16
C5 BIAS VSS 4.5852416011e-16
C6 BIAS VSS 6.0056664298e-16
C7 BIAS VSS 9.67769558653e-16
C8 DATA VSS 1.47986652206e-17
C9 DATA VSS 2.1341827174e-15
C10 DATA VSS 2.54883771702e-16
C11 DATA VSS 2.29164845676e-16
C12 DUMMY VSS 3.95129403352e-16
C13 DUMMY VSS 2.58044596648e-16
C14 GB VSS 1.51622137622e-17
C15 GB VSS 1.72426864521e-15
C16 GB VSS 7.94389567142e-16
C17 GB VSS 5.71887944535e-16
C18 GB VSS 9.74709755931e-18
C19 GB VSS 2.45767258663e-16
C20 GB VSS 4.46363441602e-16
C21 GB VSS 3.4875853898e-16
C22 GB VSS 1.40790789157e-17
C23 GB VSS 1.9537721403e-16
C24 GB VSS 1.68268151259e-16
C25 GB VSS 1.56970848339e-16
C26 GP VSS 1.52307361065e-17
C27 GP VSS 1.17626449227e-15
C28 GP VSS 9.79119080121e-18
C29 GP VSS 2.26249900732e-16
C30 GP VSS 4.19403232191e-16
C31 GP VSS 1.41428594262e-17
C32 GP VSS 3.28430744619e-16
C33 GP VSS 1.67766843858e-16
C34 OUT VSS 1.66681500308e-17
C35 OUT VSS 1.98925017131e-15
C36 OUT VSS 8.04463200934e-16
C37 OUT VSS 4.38188477724e-16
C38 VDD VSS 1.21086749973e-17
C39 VDD VSS 2.48836137077e-15
C40 VDD VSS 6.26536410376e-16
C41 VDD VSS 1.8688519979e-15
C42 VDD VSS 7.74994848121e-16
C43 VDD VSS 4.07221013496e-16
C44 VDD VSS 7.74994848121e-16
C45 VDD VSS 4.26350836219e-16
C46 VX VSS 1.6250393282e-17
C47 VX VSS 8.95073953304e-16
C48 VX VSS 4.39911429888e-16
C49 VX VSS 6.71219681741e-16
C50 VX VSS 2.21572270893e-16
C51 VX VSS 2.21572270893e-16
C52 BIAS VX 2.54311e-16
C53 GB DUMMY 1.6528e-16
C54 GP VX 1.35789e-16
C55 VDD GP 9.19938e-16
C56 DATA GB 4.15956e-16
C57 BIAS DUMMY 8.48834e-19
C58 OUT VX 3.98682e-16
C59 GP DUMMY 7.04415e-18
C60 VDD OUT 5.99649e-18
C61 DATA GP 7.28146e-18
C62 BIAS GB 8.65391e-17
C63 OUT DUMMY 2.66754e-19
C64 VDD VX 2.33108e-19
C65 GB GP 8.33624e-16
C66 VX DUMMY 4.45424e-16
C67 GB OUT 6.42302e-17
C68 VDD DATA 6.04854e-16
C69 BIAS OUT 2.11911e-16
C70 GP OUT 1.34695e-16
C71 GB VX 2.45786e-16
C72 VDD GB 1.55116e-15
.ends hs_nrz_steering_core
