* NGSPICE file created from hs_nrz_steering_core.ext - technology: gf180mcuD

.subckt hs_nrz_steering_core DATA OUT VDD VSS BIAS DUMMY
X0 VDD.t3 GB.t3 GP.t1 VDD.t2 pfet_03v3 ad=0.88p pd=4.88u as=0.88p ps=4.88u w=2u l=0.28u
X1 VX.t2 GP.t2 OUT.t1 VSS.t11 nfet_03v3 ad=0.44p pd=2.88u as=0.44p ps=2.88u w=1u l=0.28u
X2 VSS.t10 GB.t4 GP.t0 VSS.t9 nfet_03v3 ad=0.44p pd=2.88u as=0.44p ps=2.88u w=1u l=0.28u
X3 VSS.t7 DATA.t1 GB.t1 VSS.t6 nfet_03v3 ad=0.44p pd=2.88u as=0.44p ps=2.88u w=1u l=0.28u
X4 VX.t1 GB.t2 DUMMY.t0 VSS.t8 nfet_03v3 ad=0.44p pd=2.88u as=0.44p ps=2.88u w=1u l=0.28u
X5 VSS.t5 BIAS.t2 OUT.t0 VSS.t4 nfet_03v3 ad=0.88p pd=4.88u as=0.88p ps=4.88u w=2u l=1u
X6 VDD.t1 DATA.t0 GB.t0 VDD.t0 pfet_03v3 ad=0.88p pd=4.88u as=0.88p ps=4.88u w=2u l=0.28u
X7 VSS.t3 BIAS.t3 VX.t0 VSS.t2 nfet_03v3 ad=2.5344p pd=12.4u as=2.5344p ps=12.4u w=5.76u l=1u
X8 VSS.t1 BIAS.t0 BIAS.t1 VSS.t0 nfet_03v3 ad=0.88p pd=4.88u as=0.88p ps=4.88u w=2u l=1u
R0 BIAS.n2 BIAS.t3 50.8382
R1 BIAS.n0 BIAS.t0 36.8399
R2 BIAS.n1 BIAS.t2 36.6689
R3 BIAS.n0 BIAS.t1 14.7577
R4 BIAS.n2 BIAS.n1 1.3505
R5 BIAS.n1 BIAS.n0 1.1795
R6 BIAS BIAS.n2 0.0905
R7 DUMMY DUMMY.t0 16.9574
R8 OUT.n0 OUT.t0 19.5793
R9 OUT.n0 OUT.t1 18.0043
R10 OUT OUT.n0 0.0905
R11 DATA.n0 DATA.t0 70.27
R12 DATA.n0 DATA.t1 55.7659
R13 DATA DATA.n0 0.0905
R14 VDD.n2 VDD.t0 146.069
R15 VDD.n0 VDD.t2 146.069
R16 VDD.n0 VDD.t3 15.7946
R17 VDD.n1 VDD.t1 15.1421
R18 VDD.n1 VDD.n0 2.048
R19 VDD.n2 VDD.n1 0.653
R20 VDD VDD.n2 0.0905
R21 VSS.n26 VSS.n1 8369.71
R22 VSS.n27 VSS.t9 2149.07
R23 VSS.n20 VSS.n2 1581.95
R24 VSS.n28 VSS.t6 552.832
R25 VSS.t9 VSS.n26 551.792
R26 VSS.n19 VSS.n18 531.692
R27 VSS.n16 VSS.n15 481.586
R28 VSS.n25 VSS.n2 472.067
R29 VSS.n8 VSS.n7 431.798
R30 VSS.n9 VSS.n4 431.478
R31 VSS.t6 VSS.n27 407.517
R32 VSS.t4 VSS.n8 201.821
R33 VSS.n15 VSS.t2 201.821
R34 VSS.n9 VSS.t4 201.821
R35 VSS.n4 VSS.t2 201.821
R36 VSS.t11 VSS.n19 151.714
R37 VSS.n18 VSS.t8 151.714
R38 VSS.n16 VSS.t8 151.714
R39 VSS.n20 VSS.t11 151.714
R40 VSS.n27 VSS.n1 144.276
R41 VSS.n7 VSS.t0 114.492
R42 VSS.n14 VSS.n4 99.9027
R43 VSS.t9 VSS.n2 91.4677
R44 VSS.n10 VSS.n8 63.7434
R45 VSS.n28 VSS.n1 47.3183
R46 VSS.n17 VSS.n16 47.3183
R47 VSS.n21 VSS.n19 47.3183
R48 VSS.n23 VSS.t10 17.4359
R49 VSS.n0 VSS.t7 17.4359
R50 VSS.n6 VSS.t1 15.7754
R51 VSS.n5 VSS.t5 15.0419
R52 VSS.n7 VSS.n6 14.0613
R53 VSS.n29 VSS.n28 14.0218
R54 VSS.n17 VSS.n3 14.0218
R55 VSS.n22 VSS.n21 14.0218
R56 VSS.n25 VSS.n24 14.0218
R57 VSS.n11 VSS.n10 13.6394
R58 VSS.n12 VSS.t3 13.4572
R59 VSS.n14 VSS.n13 13.2432
R60 VSS.n24 VSS.n0 2.048
R61 VSS.n23 VSS.n22 2.048
R62 VSS.n22 VSS.n3 1.3505
R63 VSS.n13 VSS.n3 1.3505
R64 VSS.n21 VSS.n20 1.0405
R65 VSS.n26 VSS.n25 1.0405
R66 VSS.n18 VSS.n17 1.0405
R67 VSS.n10 VSS.n9 0.743357
R68 VSS.n11 VSS.n5 0.734
R69 VSS.n13 VSS.n12 0.734
R70 VSS.n24 VSS.n23 0.653
R71 VSS.n29 VSS.n0 0.653
R72 VSS.n6 VSS.n5 0.617
R73 VSS.n12 VSS.n11 0.617
R74 VSS.n15 VSS.n14 0.347167
R75 VSS VSS.n29 0.0905
R76 VX.n0 VX.t1 16.0148
R77 VX.n1 VX.t2 16.0148
R78 VX.n0 VX.t0 13.1252
R79 VX.n1 VX.n0 1.3505
R80 VX VX.n1 0.068
R81 GP.n0 GP.t2 55.2164
R82 GP.n3 GP.n2 14.661
R83 GP.n0 GP.t1 13.721
R84 GP.n2 GP.t0 1.6385
R85 GP.n3 GP.n0 1.3505
R86 GP.n2 GP.n1 1.1345
R87 GP GP.n3 0.068
R88 GB.n0 GB.t3 67.2148
R89 GB.n0 GB.t2 56.7606
R90 GB.n1 GB.t4 54.0607
R91 GB.n5 GB.n4 14.9452
R92 GB.n2 GB.t0 14.0052
R93 GB.n4 GB.t1 1.6385
R94 GB.n2 GB.n1 1.4405
R95 GB.n5 GB.n2 1.3505
R96 GB.n1 GB.n0 1.3505
R97 GB.n4 GB.n3 1.1345
R98 GB GB.n5 0.068
C0 VX VDD 0
C1 DUMMY BIAS 0
C2 GP DATA 0.00728f
C3 GB OUT 0.06423f
C4 GP VDD 0.91994f
C5 OUT BIAS 0.21191f
C6 GB DATA 0.41596f
C7 GB VDD 1.55116f
C8 OUT DUMMY 0
C9 GP VX 0.13579f
C10 GB VX 0.24579f
C11 VX BIAS 0.25431f
C12 VDD OUT 0.006f
C13 GB GP 0.83362f
C14 VX DUMMY 0.44542f
C15 VDD DATA 0.60485f
C16 VX OUT 0.39868f
C17 GP DUMMY 0.00704f
C18 GB BIAS 0.08654f
C19 GB DUMMY 0.16528f
C20 GP OUT 0.1347f
C21 BIAS VSS 6.06877f
 ; **nodeattr BIAS : res:drive
C22 DUMMY VSS 1.02755f
 ; **nodeattr DUMMY : res:drive
C23 OUT VSS 3.25276f
 ; **nodeattr OUT : res:drive
C24 DATA VSS 2.63881f
 ; **nodeattr DATA : res:drive
C25 VDD VSS 7.38448f
 ; **nodeattr VDD : res:drive
C26 VX VSS 2.47536f
 ; **nodeattr VX : res:drive
C27 GP VSS 2.37045f
 ; **nodeattr GP : res:drive
C28 GB VSS 4.70191f
 ; **nodeattr GB : res:drive
C29 GB.n0 VSS 1.23597f
C30 GB.n1 VSS 0.56942f
C31 GB.t0 VSS 0.29975f
C32 GB.n2 VSS 0.40993f
C33 GB.t1 VSS 0.05483f
C34 GB.n3 VSS 0.00699f
C35 GB.n4 VSS 0.17617f
C36 GB.n5 VSS 0.31996f
C37 GP.t1 VSS 0.34431f
C38 GP.n0 VSS 1.01713f
C39 GP.t0 VSS 0.06849f
C40 GP.n1 VSS 0.00847f
C41 GP.n2 VSS 0.19564f
C42 GP.n3 VSS 0.36266f
C43 VX.t0 VSS 0.44712f
C44 VX.t1 VSS 0.20304f
C45 VX.n0 VSS 0.53736f
C46 VX.t2 VSS 0.20556f
C47 VX.n1 VSS 0.2641f
C48 VSS.t7 VSS 0.04474f
C49 VSS.t5 VSS 0.0274f
C50 VSS.t1 VSS 0.02756f
C51 VSS.t3 VSS 0.04415f
C52 VSS.t10 VSS 0.05626f
C53 VDD.t3 VSS 0.23838f
C54 VDD.t2 VSS 0.32369f
C55 VDD.n0 VSS 1.03932f
C56 VDD.t1 VSS 0.21985f
C57 VDD.n1 VSS 0.26169f
C58 VDD.t0 VSS 0.32369f
C59 VDD.n2 VSS 0.78057f
C60 DATA.n0 VSS 0.83331f
C61 OUT.t0 VSS 0.22942f
C62 OUT.t1 VSS 0.18257f
C63 OUT.n0 VSS 0.49954f
C64 DUMMY.t0 VSS 0.31451f
C65 BIAS.t1 VSS 0.0694f
C66 BIAS.n0 VSS 0.12189f
C67 BIAS.n1 VSS 0.09148f
C68 BIAS.n2 VSS 0.09878f
.ends
