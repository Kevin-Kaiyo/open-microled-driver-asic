* Explicit control derived from full raw RC; original RC retained.
.subckt hs_nrz_steering_core DATA OUT VDD VSS BIAS DUMMY
X0 VDD GB GP VDD pfet_03v3 ad=0.88p pd=4.88u as=0.88p ps=4.88u w=2u l=0.28u
X1 VX GP OUT VSS nfet_03v3 ad=0.44p pd=2.88u as=0.44p ps=2.88u w=1u l=0.28u
X2 VSS GB GP VSS nfet_03v3 ad=0.44p pd=2.88u as=0.44p ps=2.88u w=1u l=0.28u
X3 VSS DATA GB VSS nfet_03v3 ad=0.44p pd=2.88u as=0.44p ps=2.88u w=1u l=0.28u
X4 VX GB DUMMY VSS nfet_03v3 ad=0.44p pd=2.88u as=0.44p ps=2.88u w=1u l=0.28u
X5 VSS BIAS OUT VSS nfet_03v3 ad=0.88p pd=4.88u as=0.88p ps=4.88u w=2u l=1u
X6 VDD DATA GB VDD pfet_03v3 ad=0.88p pd=4.88u as=0.88p ps=4.88u w=2u l=0.28u
X7 VSS BIAS VX VSS nfet_03v3 ad=2.5344p pd=12.4u as=2.5344p ps=12.4u w=5.76u l=1u
X8 VSS BIAS BIAS VSS nfet_03v3 ad=0.88p pd=4.88u as=0.88p ps=4.88u w=2u l=1u
.ends hs_nrz_steering_core
