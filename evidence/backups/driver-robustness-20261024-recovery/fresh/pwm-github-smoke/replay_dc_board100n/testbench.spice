r5 39MOS robustness: replay_dc_board100n
.include "/Users/kimmy/Projects/open-microled-driver-asic/build/github-recovery-driver-robustness-20261024/repository/build/recovery-checks/pwm-github-smoke/inputs/design.ngspice"
.lib "/Users/kimmy/Projects/open-microled-driver-asic/build/github-recovery-driver-robustness-20261024/repository/build/recovery-checks/pwm-github-smoke/inputs/sm141064.ngspice" typical
.temp 27
.param sw_stat_global=0 sw_stat_mismatch=0 LED_IS=2.2725351141552272e-20
VREFRAIL refrail_board 0 3.3
RFILTER refrail_board ref_filtered_board 100
CFILTER ref_filtered_board 0 100n
RPK_ref ref_filtered_board refrail_pkg 1.0
LPK_ref refrail_pkg refrail_pre 5e-09
VLINK_ref refrail_pre refrail 0
VSAFE saferail_board 0 3.3
RPK_safe saferail_board saferail_pkg 1.0
LPK_safe saferail_pkg saferail_pre 5e-09
VLINK_safe saferail_pre saferail 0
VBUF bufrail_board 0 3.3
RPK_buf bufrail_board bufrail_pkg 1.0
LPK_buf bufrail_pkg bufrail_pre 5e-09
VLINK_buf bufrail_pre bufrail 0
VLED rail_board 0 5.0
RPK_led rail_board rail_pkg 1.0
LPK_led rail_pkg rail_pre 5e-09
VLINK_led rail_pre rail 0
RPK_gnd 0 return_pkg 1.0
LPK_gnd return_pkg diegnd 5e-09
VLEDLOAD rail led_anode 0
VSET vset 0 .5
VRAW raw_pwm 0 3.3
VFAULT fault 0 0
VPERMIT permit 0 3.3
RFAULTPULLUP saferail fault 1Meg
RSET sense 0 5000
RBIAS pb 0 100000
RRELEASE rail fault_hb 100000
RBLEED refout 0 10000000
CCOMP n2 ctrl 30p
CSENSE sense 0 30p
.include "/Users/kimmy/Projects/open-microled-driver-asic/build/github-recovery-driver-robustness-20261024/repository/build/recovery-checks/pwm-github-smoke/inputs/dut.spice"
XDUT diegnd refrail saferail bufrail rail raw_pwm fault permit vset sense pb n2 ctrl fault_hb led_k refout bias gate pwm_b safe_out pwm_drive startup_test_macro
.include "/Users/kimmy/Projects/open-microled-driver-asic/build/github-recovery-driver-robustness-20261024/repository/build/recovery-checks/pwm-github-smoke/inputs/microled.spice"
XLED led_anode led_k microled
.options reltol=1e-7 abstol=1e-14 vntol=1e-9 method=gear maxord=2
.control
set numdgt=15
set wr_vecnames
set wr_singlescale
save all @d.xled.dled[id] @d.xled.dled[capcur]
op
wrdata waveform.dat i(VLEDLOAD) v(led_k) v(bias) v(refout) v(sense) v(n2) v(ctrl) v(refrail) v(saferail) v(bufrail) v(rail) v(diegnd) v(raw_pwm) v(fault) v(permit) v(safe_out) v(pwm_drive) v(gate) v(pb) v(fault_hb) i(VREFRAIL) i(VSAFE) i(VBUF) i(VLED) @d.xled.dled[id] @d.xled.dled[capcur]
let s_x0_gs=vecmax(abs(v(xdut.a_128036_20068.t2)-v(xdut.pwm_drive.t0)))
print s_x0_gs
let s_x0_gd=vecmax(abs(v(xdut.a_128036_20068.t2)-v(xdut.vss.t33)))
print s_x0_gd
let s_x0_gb=vecmax(abs(v(xdut.a_128036_20068.t2)-v(xdut.vss.t32)))
print s_x0_gb
let s_x0_ds=vecmax(abs(v(xdut.vss.t33)-v(xdut.pwm_drive.t0)))
print s_x0_ds
let s_x0_bs=vecmax(abs(v(xdut.vss.t32)-v(xdut.pwm_drive.t0)))
print s_x0_bs
let s_x0_bd=vecmax(abs(v(xdut.vss.t32)-v(xdut.vss.t33)))
print s_x0_bd
let s_x1_gs=vecmax(abs(v(xdut.r_n1.t1)-v(xdut.r_n1.t2)))
print s_x1_gs
let s_x1_gd=vecmax(abs(v(xdut.r_n1.t1)-v(xdut.vss.t24)))
print s_x1_gd
let s_x1_gb=vecmax(abs(v(xdut.r_n1.t1)-v(xdut.vss.t23)))
print s_x1_gb
let s_x1_ds=vecmax(abs(v(xdut.vss.t24)-v(xdut.r_n1.t2)))
print s_x1_ds
let s_x1_bs=vecmax(abs(v(xdut.vss.t23)-v(xdut.r_n1.t2)))
print s_x1_bs
let s_x1_bd=vecmax(abs(v(xdut.vss.t23)-v(xdut.vss.t24)))
print s_x1_bd
let s_x2_gs=vecmax(abs(v(xdut.safe_out.t2)-v(xdut.a_128036_20068.t1)))
print s_x2_gs
let s_x2_gd=vecmax(abs(v(xdut.safe_out.t2)-v(xdut.vss.t6)))
print s_x2_gd
let s_x2_gb=vecmax(abs(v(xdut.safe_out.t2)-v(xdut.vss.t5)))
print s_x2_gb
let s_x2_ds=vecmax(abs(v(xdut.vss.t6)-v(xdut.a_128036_20068.t1)))
print s_x2_ds
let s_x2_bs=vecmax(abs(v(xdut.vss.t5)-v(xdut.a_128036_20068.t1)))
print s_x2_bs
let s_x2_bd=vecmax(abs(v(xdut.vss.t5)-v(xdut.vss.t6)))
print s_x2_bd
let s_x3_gs=vecmax(abs(v(xdut.fault.t3)-v(xdut.bias.t1)))
print s_x3_gs
let s_x3_gd=vecmax(abs(v(xdut.fault.t3)-v(xdut.vss.t12)))
print s_x3_gd
let s_x3_gb=vecmax(abs(v(xdut.fault.t3)-v(xdut.vss.t11)))
print s_x3_gb
let s_x3_ds=vecmax(abs(v(xdut.vss.t12)-v(xdut.bias.t1)))
print s_x3_ds
let s_x3_bs=vecmax(abs(v(xdut.vss.t11)-v(xdut.bias.t1)))
print s_x3_bs
let s_x3_bd=vecmax(abs(v(xdut.vss.t11)-v(xdut.vss.t12)))
print s_x3_bd
let s_x4_gs=vecmax(abs(v(xdut.raw_pwm.t1)-v(xdut.f_nand_n.t1)))
print s_x4_gs
let s_x4_gd=vecmax(abs(v(xdut.raw_pwm.t1)-v(xdut.vsafe.t3)))
print s_x4_gd
let s_x4_gb=vecmax(abs(v(xdut.raw_pwm.t1)-v(xdut.vsafe.t2)))
print s_x4_gb
let s_x4_ds=vecmax(abs(v(xdut.vsafe.t3)-v(xdut.f_nand_n.t1)))
print s_x4_ds
let s_x4_bs=vecmax(abs(v(xdut.vsafe.t2)-v(xdut.f_nand_n.t1)))
print s_x4_bs
let s_x4_bd=vecmax(abs(v(xdut.vsafe.t2)-v(xdut.vsafe.t3)))
print s_x4_bd
let s_x5_gs=vecmax(abs(v(xdut.f_fault_b.t2)-v(xdut.f_stack2.t1)))
print s_x5_gs
let s_x5_gd=vecmax(abs(v(xdut.f_fault_b.t2)-v(xdut.vss.t29)))
print s_x5_gd
let s_x5_gb=vecmax(abs(v(xdut.f_fault_b.t2)-v(xdut.vss.t28)))
print s_x5_gb
let s_x5_ds=vecmax(abs(v(xdut.vss.t29)-v(xdut.f_stack2.t1)))
print s_x5_ds
let s_x5_bs=vecmax(abs(v(xdut.vss.t28)-v(xdut.f_stack2.t1)))
print s_x5_bs
let s_x5_bd=vecmax(abs(v(xdut.vss.t28)-v(xdut.vss.t29)))
print s_x5_bd
let s_x6_gs=vecmax(abs(v(xdut.sense.t1)-v(xdut.n2.t1)))
print s_x6_gs
let s_x6_gd=vecmax(abs(v(xdut.sense.t1)-v(xdut.r_tail.t0)))
print s_x6_gd
let s_x6_gb=vecmax(abs(v(xdut.sense.t1)-v(xdut.vref.t6)))
print s_x6_gb
let s_x6_ds=vecmax(abs(v(xdut.r_tail.t0)-v(xdut.n2.t1)))
print s_x6_ds
let s_x6_bs=vecmax(abs(v(xdut.vref.t6)-v(xdut.n2.t1)))
print s_x6_bs
let s_x6_bd=vecmax(abs(v(xdut.vref.t6)-v(xdut.r_tail.t0)))
print s_x6_bd
let s_x7_gs=vecmax(abs(v(xdut.i_fault_b.t2)-v(xdut.refout.t1)))
print s_x7_gs
let s_x7_gd=vecmax(abs(v(xdut.i_fault_b.t2)-v(xdut.bias.t5)))
print s_x7_gd
let s_x7_gb=vecmax(abs(v(xdut.i_fault_b.t2)-v(xdut.vss.t25)))
print s_x7_gb
let s_x7_ds=vecmax(abs(v(xdut.bias.t5)-v(xdut.refout.t1)))
print s_x7_ds
let s_x7_bs=vecmax(abs(v(xdut.vss.t25)-v(xdut.refout.t1)))
print s_x7_bs
let s_x7_bd=vecmax(abs(v(xdut.vss.t25)-v(xdut.bias.t5)))
print s_x7_bd
let s_x8_gs=vecmax(abs(v(xdut.f_fault_b.t3)-v(xdut.f_nand_n.t3)))
print s_x8_gs
let s_x8_gd=vecmax(abs(v(xdut.f_fault_b.t3)-v(xdut.vsafe.t10)))
print s_x8_gd
let s_x8_gb=vecmax(abs(v(xdut.f_fault_b.t3)-v(xdut.vsafe.t9)))
print s_x8_gb
let s_x8_ds=vecmax(abs(v(xdut.vsafe.t10)-v(xdut.f_nand_n.t3)))
print s_x8_ds
let s_x8_bs=vecmax(abs(v(xdut.vsafe.t9)-v(xdut.f_nand_n.t3)))
print s_x8_bs
let s_x8_bd=vecmax(abs(v(xdut.vsafe.t9)-v(xdut.vsafe.t10)))
print s_x8_bd
let s_x9_gs=vecmax(abs(v(xdut.bias.t3)-v(xdut.bias.t4)))
print s_x9_gs
let s_x9_gd=vecmax(abs(v(xdut.bias.t3)-v(xdut.vss.t20)))
print s_x9_gd
let s_x9_gb=vecmax(abs(v(xdut.bias.t3)-v(xdut.vss.t19)))
print s_x9_gb
let s_x9_ds=vecmax(abs(v(xdut.vss.t20)-v(xdut.bias.t4)))
print s_x9_ds
let s_x9_bs=vecmax(abs(v(xdut.vss.t19)-v(xdut.bias.t4)))
print s_x9_bs
let s_x9_bd=vecmax(abs(v(xdut.vss.t19)-v(xdut.vss.t20)))
print s_x9_bd
let s_x10_gs=vecmax(abs(v(xdut.f_nand_n.t5)-v(xdut.safe_out.t0)))
print s_x10_gs
let s_x10_gd=vecmax(abs(v(xdut.f_nand_n.t5)-v(xdut.vss.t31)))
print s_x10_gd
let s_x10_gb=vecmax(abs(v(xdut.f_nand_n.t5)-v(xdut.vss.t30)))
print s_x10_gb
let s_x10_ds=vecmax(abs(v(xdut.vss.t31)-v(xdut.safe_out.t0)))
print s_x10_ds
let s_x10_bs=vecmax(abs(v(xdut.vss.t30)-v(xdut.safe_out.t0)))
print s_x10_bs
let s_x10_bd=vecmax(abs(v(xdut.vss.t30)-v(xdut.vss.t31)))
print s_x10_bd
let s_x11_gs=vecmax(abs(v(xdut.a_128036_20068.t5)-v(xdut.vbuf.t7)))
print s_x11_gs
let s_x11_gd=vecmax(abs(v(xdut.a_128036_20068.t5)-v(xdut.pwm_drive.t3)))
print s_x11_gd
let s_x11_gb=vecmax(abs(v(xdut.a_128036_20068.t5)-v(xdut.vbuf.t6)))
print s_x11_gb
let s_x11_ds=vecmax(abs(v(xdut.pwm_drive.t3)-v(xdut.vbuf.t7)))
print s_x11_ds
let s_x11_bs=vecmax(abs(v(xdut.vbuf.t6)-v(xdut.vbuf.t7)))
print s_x11_bs
let s_x11_bd=vecmax(abs(v(xdut.vbuf.t6)-v(xdut.pwm_drive.t3)))
print s_x11_bd
let s_x12_gs=vecmax(abs(v(xdut.fault.t0)-v(xdut.fault_hb.t0)))
print s_x12_gs
let s_x12_gd=vecmax(abs(v(xdut.fault.t0)-v(xdut.vss.t14)))
print s_x12_gd
let s_x12_gb=vecmax(abs(v(xdut.fault.t0)-v(xdut.vss.t13)))
print s_x12_gb
let s_x12_ds=vecmax(abs(v(xdut.vss.t14)-v(xdut.fault_hb.t0)))
print s_x12_ds
let s_x12_bs=vecmax(abs(v(xdut.vss.t13)-v(xdut.fault_hb.t0)))
print s_x12_bs
let s_x12_bd=vecmax(abs(v(xdut.vss.t13)-v(xdut.vss.t14)))
print s_x12_bd
let s_x13_gs=vecmax(abs(v(xdut.pwm_drive.t6)-v(xdut.bias.t0)))
print s_x13_gs
let s_x13_gd=vecmax(abs(v(xdut.pwm_drive.t6)-v(xdut.gate.t1)))
print s_x13_gd
let s_x13_gb=vecmax(abs(v(xdut.pwm_drive.t6)-v(xdut.vss.t2)))
print s_x13_gb
let s_x13_ds=vecmax(abs(v(xdut.gate.t1)-v(xdut.bias.t0)))
print s_x13_ds
let s_x13_bs=vecmax(abs(v(xdut.vss.t2)-v(xdut.bias.t0)))
print s_x13_bs
let s_x13_bd=vecmax(abs(v(xdut.vss.t2)-v(xdut.gate.t1)))
print s_x13_bd
let s_x14_gs=vecmax(abs(v(xdut.pwm_drive.t4)-v(xdut.pwm_b.t0)))
print s_x14_gs
let s_x14_gd=vecmax(abs(v(xdut.pwm_drive.t4)-v(xdut.vbuf.t1)))
print s_x14_gd
let s_x14_gb=vecmax(abs(v(xdut.pwm_drive.t4)-v(xdut.vbuf.t0)))
print s_x14_gb
let s_x14_ds=vecmax(abs(v(xdut.vbuf.t1)-v(xdut.pwm_b.t0)))
print s_x14_ds
let s_x14_bs=vecmax(abs(v(xdut.vbuf.t0)-v(xdut.pwm_b.t0)))
print s_x14_bs
let s_x14_bd=vecmax(abs(v(xdut.vbuf.t0)-v(xdut.vbuf.t1)))
print s_x14_bd
let s_x15_gs=vecmax(abs(v(xdut.fault.t5)-v(xdut.i_fault_b.t1)))
print s_x15_gs
let s_x15_gd=vecmax(abs(v(xdut.fault.t5)-v(xdut.vss.t18)))
print s_x15_gd
let s_x15_gb=vecmax(abs(v(xdut.fault.t5)-v(xdut.vss.t17)))
print s_x15_gb
let s_x15_ds=vecmax(abs(v(xdut.vss.t18)-v(xdut.i_fault_b.t1)))
print s_x15_ds
let s_x15_bs=vecmax(abs(v(xdut.vss.t17)-v(xdut.i_fault_b.t1)))
print s_x15_bs
let s_x15_bd=vecmax(abs(v(xdut.vss.t17)-v(xdut.vss.t18)))
print s_x15_bd
let s_x16_gs=vecmax(abs(v(xdut.ctrl.t4)-v(xdut.sense.t0)))
print s_x16_gs
let s_x16_gd=vecmax(abs(v(xdut.ctrl.t4)-v(xdut.vref.t5)))
print s_x16_gd
let s_x16_gb=vecmax(abs(v(xdut.ctrl.t4)-v(xdut.vref.t4)))
print s_x16_gb
let s_x16_ds=vecmax(abs(v(xdut.vref.t5)-v(xdut.sense.t0)))
print s_x16_ds
let s_x16_bs=vecmax(abs(v(xdut.vref.t4)-v(xdut.sense.t0)))
print s_x16_bs
let s_x16_bd=vecmax(abs(v(xdut.vref.t4)-v(xdut.vref.t5)))
print s_x16_bd
let s_x17_gs=vecmax(abs(v(xdut.fault.t4)-v(xdut.i_fault_b.t0)))
print s_x17_gs
let s_x17_gd=vecmax(abs(v(xdut.fault.t4)-v(xdut.vsafe.t5)))
print s_x17_gd
let s_x17_gb=vecmax(abs(v(xdut.fault.t4)-v(xdut.vsafe.t4)))
print s_x17_gb
let s_x17_ds=vecmax(abs(v(xdut.vsafe.t5)-v(xdut.i_fault_b.t0)))
print s_x17_ds
let s_x17_bs=vecmax(abs(v(xdut.vsafe.t4)-v(xdut.i_fault_b.t0)))
print s_x17_bs
let s_x17_bd=vecmax(abs(v(xdut.vsafe.t4)-v(xdut.vsafe.t5)))
print s_x17_bd
let s_x18_gs=vecmax(abs(v(xdut.vset.t0)-v(xdut.r_n1.t0)))
print s_x18_gs
let s_x18_gd=vecmax(abs(v(xdut.vset.t0)-v(xdut.r_tail.t1)))
print s_x18_gd
let s_x18_gb=vecmax(abs(v(xdut.vset.t0)-v(xdut.vref.t7)))
print s_x18_gb
let s_x18_ds=vecmax(abs(v(xdut.r_tail.t1)-v(xdut.r_n1.t0)))
print s_x18_ds
let s_x18_bs=vecmax(abs(v(xdut.vref.t7)-v(xdut.r_n1.t0)))
print s_x18_bs
let s_x18_bd=vecmax(abs(v(xdut.vref.t7)-v(xdut.r_tail.t1)))
print s_x18_bd
let s_x19_gs=vecmax(abs(v(xdut.n2.t2)-v(xdut.ctrl.t2)))
print s_x19_gs
let s_x19_gd=vecmax(abs(v(xdut.n2.t2)-v(xdut.vss.t22)))
print s_x19_gd
let s_x19_gb=vecmax(abs(v(xdut.n2.t2)-v(xdut.vss.t21)))
print s_x19_gb
let s_x19_ds=vecmax(abs(v(xdut.vss.t22)-v(xdut.ctrl.t2)))
print s_x19_ds
let s_x19_bs=vecmax(abs(v(xdut.vss.t21)-v(xdut.ctrl.t2)))
print s_x19_bs
let s_x19_bd=vecmax(abs(v(xdut.vss.t21)-v(xdut.vss.t22)))
print s_x19_bd
let s_x20_gs=vecmax(abs(v(xdut.fault.t6)-v(xdut.bias.t2)))
print s_x20_gs
let s_x20_gd=vecmax(abs(v(xdut.fault.t6)-v(xdut.refout.t0)))
print s_x20_gd
let s_x20_gb=vecmax(abs(v(xdut.fault.t6)-v(xdut.vsafe.t8)))
print s_x20_gb
let s_x20_ds=vecmax(abs(v(xdut.refout.t0)-v(xdut.bias.t2)))
print s_x20_ds
let s_x20_bs=vecmax(abs(v(xdut.vsafe.t8)-v(xdut.bias.t2)))
print s_x20_bs
let s_x20_bd=vecmax(abs(v(xdut.vsafe.t8)-v(xdut.refout.t0)))
print s_x20_bd
let s_x21_gs=vecmax(abs(v(xdut.pb.t0)-v(xdut.pb.t1)))
print s_x21_gs
let s_x21_gd=vecmax(abs(v(xdut.pb.t0)-v(xdut.vref.t11)))
print s_x21_gd
let s_x21_gb=vecmax(abs(v(xdut.pb.t0)-v(xdut.vref.t10)))
print s_x21_gb
let s_x21_ds=vecmax(abs(v(xdut.vref.t11)-v(xdut.pb.t1)))
print s_x21_ds
let s_x21_bs=vecmax(abs(v(xdut.vref.t10)-v(xdut.pb.t1)))
print s_x21_bs
let s_x21_bd=vecmax(abs(v(xdut.vref.t10)-v(xdut.vref.t11)))
print s_x21_bd
let s_x22_gs=vecmax(abs(v(xdut.raw_pwm.t0)-v(xdut.f_nand_n.t2)))
print s_x22_gs
let s_x22_gd=vecmax(abs(v(xdut.raw_pwm.t0)-v(xdut.f_stack1.t1)))
print s_x22_gd
let s_x22_gb=vecmax(abs(v(xdut.raw_pwm.t0)-v(xdut.vss.t8)))
print s_x22_gb
let s_x22_ds=vecmax(abs(v(xdut.f_stack1.t1)-v(xdut.f_nand_n.t2)))
print s_x22_ds
let s_x22_bs=vecmax(abs(v(xdut.vss.t8)-v(xdut.f_nand_n.t2)))
print s_x22_bs
let s_x22_bd=vecmax(abs(v(xdut.vss.t8)-v(xdut.f_stack1.t1)))
print s_x22_bd
let s_x23_gs=vecmax(abs(v(xdut.safe_out.t3)-v(xdut.a_128036_20068.t0)))
print s_x23_gs
let s_x23_gd=vecmax(abs(v(xdut.safe_out.t3)-v(xdut.vbuf.t3)))
print s_x23_gd
let s_x23_gb=vecmax(abs(v(xdut.safe_out.t3)-v(xdut.vbuf.t2)))
print s_x23_gb
let s_x23_ds=vecmax(abs(v(xdut.vbuf.t3)-v(xdut.a_128036_20068.t0)))
print s_x23_ds
let s_x23_bs=vecmax(abs(v(xdut.vbuf.t2)-v(xdut.a_128036_20068.t0)))
print s_x23_bs
let s_x23_bd=vecmax(abs(v(xdut.vbuf.t2)-v(xdut.vbuf.t3)))
print s_x23_bd
let s_x24_gs=vecmax(abs(v(xdut.a_128036_20068.t4)-v(xdut.pwm_drive.t2)))
print s_x24_gs
let s_x24_gd=vecmax(abs(v(xdut.a_128036_20068.t4)-v(xdut.vbuf.t5)))
print s_x24_gd
let s_x24_gb=vecmax(abs(v(xdut.a_128036_20068.t4)-v(xdut.vbuf.t4)))
print s_x24_gb
let s_x24_ds=vecmax(abs(v(xdut.vbuf.t5)-v(xdut.pwm_drive.t2)))
print s_x24_ds
let s_x24_bs=vecmax(abs(v(xdut.vbuf.t4)-v(xdut.pwm_drive.t2)))
print s_x24_bs
let s_x24_bd=vecmax(abs(v(xdut.vbuf.t4)-v(xdut.vbuf.t5)))
print s_x24_bd
let s_x25_gs=vecmax(abs(v(xdut.gate.t2)-v(xdut.led_k.t1)))
print s_x25_gs
let s_x25_gd=vecmax(abs(v(xdut.gate.t2)-v(xdut.vss.t10)))
print s_x25_gd
let s_x25_gb=vecmax(abs(v(xdut.gate.t2)-v(xdut.vss.t9)))
print s_x25_gb
let s_x25_ds=vecmax(abs(v(xdut.vss.t10)-v(xdut.led_k.t1)))
print s_x25_ds
let s_x25_bs=vecmax(abs(v(xdut.vss.t9)-v(xdut.led_k.t1)))
print s_x25_bs
let s_x25_bd=vecmax(abs(v(xdut.vss.t9)-v(xdut.vss.t10)))
print s_x25_bd
let s_x26_gs=vecmax(abs(v(xdut.pwm_b.t2)-v(xdut.gate.t0)))
print s_x26_gs
let s_x26_gd=vecmax(abs(v(xdut.pwm_b.t2)-v(xdut.vss.t1)))
print s_x26_gd
let s_x26_gb=vecmax(abs(v(xdut.pwm_b.t2)-v(xdut.vss.t0)))
print s_x26_gb
let s_x26_ds=vecmax(abs(v(xdut.vss.t1)-v(xdut.gate.t0)))
print s_x26_ds
let s_x26_bs=vecmax(abs(v(xdut.vss.t0)-v(xdut.gate.t0)))
print s_x26_bs
let s_x26_bd=vecmax(abs(v(xdut.vss.t0)-v(xdut.vss.t1)))
print s_x26_bd
let s_x27_gs=vecmax(abs(v(xdut.pb.t2)-v(xdut.r_tail.t2)))
print s_x27_gs
let s_x27_gd=vecmax(abs(v(xdut.pb.t2)-v(xdut.vref.t9)))
print s_x27_gd
let s_x27_gb=vecmax(abs(v(xdut.pb.t2)-v(xdut.vref.t8)))
print s_x27_gb
let s_x27_ds=vecmax(abs(v(xdut.vref.t9)-v(xdut.r_tail.t2)))
print s_x27_ds
let s_x27_bs=vecmax(abs(v(xdut.vref.t8)-v(xdut.r_tail.t2)))
print s_x27_bs
let s_x27_bd=vecmax(abs(v(xdut.vref.t8)-v(xdut.vref.t9)))
print s_x27_bd
let s_x28_gs=vecmax(abs(v(xdut.ctrl.t3)-v(xdut.refout.t2)))
print s_x28_gs
let s_x28_gd=vecmax(abs(v(xdut.ctrl.t3)-v(xdut.vref.t1)))
print s_x28_gd
let s_x28_gb=vecmax(abs(v(xdut.ctrl.t3)-v(xdut.vref.t0)))
print s_x28_gb
let s_x28_ds=vecmax(abs(v(xdut.vref.t1)-v(xdut.refout.t2)))
print s_x28_ds
let s_x28_bs=vecmax(abs(v(xdut.vref.t0)-v(xdut.refout.t2)))
print s_x28_bs
let s_x28_bd=vecmax(abs(v(xdut.vref.t0)-v(xdut.vref.t1)))
print s_x28_bd
let s_x29_gs=vecmax(abs(v(xdut.fault.t2)-v(xdut.f_fault_b.t1)))
print s_x29_gs
let s_x29_gd=vecmax(abs(v(xdut.fault.t2)-v(xdut.vss.t16)))
print s_x29_gd
let s_x29_gb=vecmax(abs(v(xdut.fault.t2)-v(xdut.vss.t15)))
print s_x29_gb
let s_x29_ds=vecmax(abs(v(xdut.vss.t16)-v(xdut.f_fault_b.t1)))
print s_x29_ds
let s_x29_bs=vecmax(abs(v(xdut.vss.t15)-v(xdut.f_fault_b.t1)))
print s_x29_bs
let s_x29_bd=vecmax(abs(v(xdut.vss.t15)-v(xdut.vss.t16)))
print s_x29_bd
let s_x30_gs=vecmax(abs(v(xdut.a_128036_20068.t3)-v(xdut.vss.t35)))
print s_x30_gs
let s_x30_gd=vecmax(abs(v(xdut.a_128036_20068.t3)-v(xdut.pwm_drive.t1)))
print s_x30_gd
let s_x30_gb=vecmax(abs(v(xdut.a_128036_20068.t3)-v(xdut.vss.t34)))
print s_x30_gb
let s_x30_ds=vecmax(abs(v(xdut.pwm_drive.t1)-v(xdut.vss.t35)))
print s_x30_ds
let s_x30_bs=vecmax(abs(v(xdut.vss.t34)-v(xdut.vss.t35)))
print s_x30_bs
let s_x30_bd=vecmax(abs(v(xdut.vss.t34)-v(xdut.pwm_drive.t1)))
print s_x30_bd
let s_x31_gs=vecmax(abs(v(xdut.ctrl.t0)-v(xdut.ctrl.t1)))
print s_x31_gs
let s_x31_gd=vecmax(abs(v(xdut.ctrl.t0)-v(xdut.vref.t3)))
print s_x31_gd
let s_x31_gb=vecmax(abs(v(xdut.ctrl.t0)-v(xdut.vref.t2)))
print s_x31_gb
let s_x31_ds=vecmax(abs(v(xdut.vref.t3)-v(xdut.ctrl.t1)))
print s_x31_ds
let s_x31_bs=vecmax(abs(v(xdut.vref.t2)-v(xdut.ctrl.t1)))
print s_x31_bs
let s_x31_bd=vecmax(abs(v(xdut.vref.t2)-v(xdut.vref.t3)))
print s_x31_bd
let s_x32_gs=vecmax(abs(v(xdut.fault.t1)-v(xdut.f_fault_b.t0)))
print s_x32_gs
let s_x32_gd=vecmax(abs(v(xdut.fault.t1)-v(xdut.vsafe.t7)))
print s_x32_gd
let s_x32_gb=vecmax(abs(v(xdut.fault.t1)-v(xdut.vsafe.t6)))
print s_x32_gb
let s_x32_ds=vecmax(abs(v(xdut.vsafe.t7)-v(xdut.f_fault_b.t0)))
print s_x32_ds
let s_x32_bs=vecmax(abs(v(xdut.vsafe.t6)-v(xdut.f_fault_b.t0)))
print s_x32_bs
let s_x32_bd=vecmax(abs(v(xdut.vsafe.t6)-v(xdut.vsafe.t7)))
print s_x32_bd
let s_x33_gs=vecmax(abs(v(xdut.permit.t1)-v(xdut.f_nand_n.t0)))
print s_x33_gs
let s_x33_gd=vecmax(abs(v(xdut.permit.t1)-v(xdut.vsafe.t1)))
print s_x33_gd
let s_x33_gb=vecmax(abs(v(xdut.permit.t1)-v(xdut.vsafe.t0)))
print s_x33_gb
let s_x33_ds=vecmax(abs(v(xdut.vsafe.t1)-v(xdut.f_nand_n.t0)))
print s_x33_ds
let s_x33_bs=vecmax(abs(v(xdut.vsafe.t0)-v(xdut.f_nand_n.t0)))
print s_x33_bs
let s_x33_bd=vecmax(abs(v(xdut.vsafe.t0)-v(xdut.vsafe.t1)))
print s_x33_bd
let s_x34_gs=vecmax(abs(v(xdut.permit.t0)-v(xdut.f_stack1.t0)))
print s_x34_gs
let s_x34_gd=vecmax(abs(v(xdut.permit.t0)-v(xdut.f_stack2.t0)))
print s_x34_gd
let s_x34_gb=vecmax(abs(v(xdut.permit.t0)-v(xdut.vss.t7)))
print s_x34_gb
let s_x34_ds=vecmax(abs(v(xdut.f_stack2.t0)-v(xdut.f_stack1.t0)))
print s_x34_ds
let s_x34_bs=vecmax(abs(v(xdut.vss.t7)-v(xdut.f_stack1.t0)))
print s_x34_bs
let s_x34_bd=vecmax(abs(v(xdut.vss.t7)-v(xdut.f_stack2.t0)))
print s_x34_bd
let s_x35_gs=vecmax(abs(v(xdut.f_nand_n.t4)-v(xdut.safe_out.t1)))
print s_x35_gs
let s_x35_gd=vecmax(abs(v(xdut.f_nand_n.t4)-v(xdut.vsafe.t12)))
print s_x35_gd
let s_x35_gb=vecmax(abs(v(xdut.f_nand_n.t4)-v(xdut.vsafe.t11)))
print s_x35_gb
let s_x35_ds=vecmax(abs(v(xdut.vsafe.t12)-v(xdut.safe_out.t1)))
print s_x35_ds
let s_x35_bs=vecmax(abs(v(xdut.vsafe.t11)-v(xdut.safe_out.t1)))
print s_x35_bs
let s_x35_bd=vecmax(abs(v(xdut.vsafe.t11)-v(xdut.vsafe.t12)))
print s_x35_bd
let s_x36_gs=vecmax(abs(v(xdut.r_n1.t3)-v(xdut.n2.t0)))
print s_x36_gs
let s_x36_gd=vecmax(abs(v(xdut.r_n1.t3)-v(xdut.vss.t27)))
print s_x36_gd
let s_x36_gb=vecmax(abs(v(xdut.r_n1.t3)-v(xdut.vss.t26)))
print s_x36_gb
let s_x36_ds=vecmax(abs(v(xdut.vss.t27)-v(xdut.n2.t0)))
print s_x36_ds
let s_x36_bs=vecmax(abs(v(xdut.vss.t26)-v(xdut.n2.t0)))
print s_x36_bs
let s_x36_bd=vecmax(abs(v(xdut.vss.t26)-v(xdut.vss.t27)))
print s_x36_bd
let s_x37_gs=vecmax(abs(v(xdut.fault_hb.t1)-v(xdut.led_k.t0)))
print s_x37_gs
let s_x37_gd=vecmax(abs(v(xdut.fault_hb.t1)-v(xdut.led_a.t1)))
print s_x37_gd
let s_x37_gb=vecmax(abs(v(xdut.fault_hb.t1)-v(xdut.led_a.t0)))
print s_x37_gb
let s_x37_ds=vecmax(abs(v(xdut.led_a.t1)-v(xdut.led_k.t0)))
print s_x37_ds
let s_x37_bs=vecmax(abs(v(xdut.led_a.t0)-v(xdut.led_k.t0)))
print s_x37_bs
let s_x37_bd=vecmax(abs(v(xdut.led_a.t0)-v(xdut.led_a.t1)))
print s_x37_bd
let s_x38_gs=vecmax(abs(v(xdut.pwm_drive.t5)-v(xdut.pwm_b.t1)))
print s_x38_gs
let s_x38_gd=vecmax(abs(v(xdut.pwm_drive.t5)-v(xdut.vss.t4)))
print s_x38_gd
let s_x38_gb=vecmax(abs(v(xdut.pwm_drive.t5)-v(xdut.vss.t3)))
print s_x38_gb
let s_x38_ds=vecmax(abs(v(xdut.vss.t4)-v(xdut.pwm_b.t1)))
print s_x38_ds
let s_x38_bs=vecmax(abs(v(xdut.vss.t3)-v(xdut.pwm_b.t1)))
print s_x38_bs
let s_x38_bd=vecmax(abs(v(xdut.vss.t3)-v(xdut.vss.t4)))
print s_x38_bd
quit
.endc
.end
