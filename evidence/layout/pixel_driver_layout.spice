* NGSPICE file created from pixel_driver_layout.ext - technology: gf180mcuD

.subckt pixel_driver_layout VSS bias gate pwm pwm_b led_k vlogic
X0 VSS pwm_b gate VSS nfet_06v0 ad=0.88p pd=4.88u as=0.88p ps=4.88u w=2u l=1u
X1 vlogic pwm pwm_b vlogic pfet_06v0 ad=1.76p pd=8.88u as=1.76p ps=8.88u w=4u l=1u
X2 VSS gate led_k VSS nfet_06v0 ad=8.8p pd=40.88u as=8.8p ps=40.88u w=20u l=4u
X3 gate pwm bias VSS nfet_06v0 ad=0.88p pd=4.88u as=0.88p ps=4.88u w=2u l=1u
X4 VSS bias bias VSS nfet_06v0 ad=8.8p pd=40.88u as=8.8p ps=40.88u w=20u l=4u
X5 VSS pwm pwm_b VSS nfet_06v0 ad=0.88p pd=4.88u as=0.88p ps=4.88u w=2u l=1u
.ends
