* NGSPICE file created from pixel_driver_layout.ext - technology: gf180mcuD

.subckt pixel_driver_layout VSS bias gate pwm pwm_b led_k vlogic
X0 VSS.t1 pwm_b.t2 gate.t0 VSS.t0 nfet_06v0 ad=0.88p pd=4.88u as=0.88p ps=4.88u w=2u l=1u
X1 vlogic.t1 pwm.t0 pwm_b.t1 vlogic.t0 pfet_06v0 ad=1.76p pd=8.88u as=1.76p ps=8.88u w=4u l=1u
X2 VSS.t6 gate.t2 led_k.t0 VSS.t5 nfet_06v0 ad=4.4p pd=20.88u as=4.4p ps=20.88u w=10u l=2u
X3 gate.t1 pwm.t2 bias.t0 VSS.t2 nfet_06v0 ad=0.88p pd=4.88u as=0.88p ps=4.88u w=2u l=1u
X4 VSS.t8 bias.t1 bias.t2 VSS.t7 nfet_06v0 ad=4.4p pd=20.88u as=4.4p ps=20.88u w=10u l=2u
X5 VSS.t4 pwm.t1 pwm_b.t0 VSS.t3 nfet_06v0 ad=0.88p pd=4.88u as=0.88p ps=4.88u w=2u l=1u
R0 pwm_b.n1 pwm_b.t2 24.7475
R1 pwm_b.n0 pwm_b.t1 15.0465
R2 pwm_b.n0 pwm_b.t0 14.0855
R3 pwm_b pwm_b.n1 8.2505
R4 pwm_b.n1 pwm_b.n0 2.1365
R5 pwm.n0 pwm.t0 34.5225
R6 pwm.n1 pwm.t2 25.1975
R7 pwm.n0 pwm.t1 25.1975
R8 pwm pwm.n1 6.0005
R9 pwm.n1 pwm.n0 4.5005
R10 led_k led_k.t0 15.2663
R11 gate.n1 gate.t2 32.6755
R12 gate.n0 gate.t0 17.0075
R13 gate.n0 gate.t1 14.9855
R14 gate gate.n1 3.7505
R15 gate.n1 gate.n0 2.3645
R16 bias.n0 bias.t1 33.1255
R17 bias.n0 bias.t0 19.8215
R18 bias.n1 bias.t2 13.5053
R19 bias bias.n1 1.3115
R20 bias.n1 bias.n0 0.1895
R21 vlogic.n0 vlogic.t0 124.925
R22 vlogic.n0 vlogic.t1 12.5355
R23 vlogic vlogic.n0 12.2255
R24 VSS.n6 VSS.n5 1472.88
R25 VSS.n9 VSS.n8 1472.16
R26 VSS.n10 VSS.n1 1411.02
R27 VSS.n17 VSS.n16 1351.56
R28 VSS.n16 VSS.t5 242.1
R29 VSS.n1 VSS.t5 242.1
R30 VSS.n6 VSS.t0 180.964
R31 VSS.n8 VSS.t0 180.964
R32 VSS.t2 VSS.n9 180.964
R33 VSS.n10 VSS.t2 180.964
R34 VSS.n17 VSS.t7 120.322
R35 VSS.n5 VSS.t3 90.7776
R36 VSS.n4 VSS.t4 16.5245
R37 VSS.n3 VSS.t1 15.8855
R38 VSS.n18 VSS.n17 15.435
R39 VSS.n5 VSS.n4 14.6004
R40 VSS.n13 VSS.t6 13.9553
R41 VSS.n0 VSS.t8 13.9553
R42 VSS.n12 VSS.n11 13.8691
R43 VSS.n7 VSS.n2 13.8691
R44 VSS.n15 VSS.n14 13.7611
R45 VSS.n15 VSS.n1 3.36758
R46 VSS.n7 VSS.n6 2.64852
R47 VSS.n11 VSS.n9 2.64852
R48 VSS.n12 VSS.n2 2.2505
R49 VSS.n4 VSS.n3 1.6115
R50 VSS.n13 VSS.n12 1.5365
R51 VSS.n14 VSS.n0 1.5365
R52 VSS.n11 VSS.n10 1.45586
R53 VSS.n8 VSS.n7 1.45586
R54 VSS VSS.n18 0.9755
R55 VSS.n18 VSS.n0 0.7145
R56 VSS.n14 VSS.n13 0.7145
R57 VSS.n3 VSS.n2 0.6395
R58 VSS.n16 VSS.n15 0.429494
C0 led_k pwm 0.16852f
C1 gate pwm_b 0.69607f
C2 gate pwm 2.54992f
C3 bias pwm_b 0.1921f
C4 vlogic pwm_b 0.82537f
C5 bias pwm 0.76619f
C6 gate led_k 0.69265f
C7 bias led_k 0.19185f
C8 vlogic pwm 1.069f
C9 vlogic led_k 1.84348f
C10 bias gate 2.0707f
C11 vlogic gate 0.22978f
C12 pwm pwm_b 2.94805f
C13 vlogic bias 0.23105f
C14 led_k pwm_b 1.94809f
C15 pwm_b VSS 5.68674f
C16 pwm VSS 5.6772f
C17 led_k VSS 6.62839f
C18 gate VSS 6.30295f
C19 bias VSS 8.16677f
C20 vlogic VSS 9.63155f
C21 VSS.t8 VSS 0.3212f
C22 VSS.t4 VSS 0.18905f
C23 VSS.t1 VSS 0.1694f
C24 VSS.t6 VSS 0.61861f
C25 vlogic.t1 VSS 0.48148f
C26 vlogic.t0 VSS 0.50578f
C27 vlogic.n0 VSS 2.49371f
C28 bias.t0 VSS 0.66191f
C29 bias.n0 VSS 1.70232f
C30 bias.t2 VSS 0.65096f
C31 bias.n1 VSS 0.22119f
C32 gate.t0 VSS 0.66786f
C33 gate.t1 VSS 0.44855f
C34 gate.n0 VSS 2.55994f
C35 gate.n1 VSS 1.21984f
C36 led_k.t0 VSS 2.11015f
C37 pwm.n0 VSS 2.865f
C38 pwm.n1 VSS 2.25147f
C39 pwm_b.t1 VSS 0.87738f
C40 pwm_b.t0 VSS 0.47863f
C41 pwm_b.n0 VSS 1.9611f
C42 pwm_b.n1 VSS 2.05889f
.ends
