* Explicit control derived from full raw RC; original RC retained.
.subckt hs_steering_robust DATA OUT VDD VSS BIAS DUMMY
X0 VSS DI GB VSS nfet_06v0 ad=1.1p pd=5.88u as=1.1p ps=5.88u w=2.5u l=0.7u
X2 VX GB DUMMY VSS nfet_06v0 ad=1.1p pd=5.88u as=1.1p ps=5.88u w=2.5u l=0.7u
X3 VSS BIAS OUT VSS nfet_03v3 ad=0.88p pd=4.88u as=0.88p ps=4.88u w=2u l=1u
X4 VX GP OUT VSS nfet_06v0 ad=1.1p pd=5.88u as=1.1p ps=5.88u w=2.5u l=0.7u
X5 VDD DI GB VDD pfet_06v0 ad=1.7292p pd=8.74u as=1.7292p ps=8.74u w=3.93u l=0.55u
X6 VSS BIAS VX VSS nfet_03v3 ad=2.5344p pd=12.4u as=2.5344p ps=12.4u w=5.76u l=1u
X7 VSS BIAS BIAS VSS nfet_03v3 ad=0.88p pd=4.88u as=0.88p ps=4.88u w=2u l=1u
X8 VSS GB GP VSS nfet_06v0 ad=1.1p pd=5.88u as=1.1p ps=5.88u w=2.5u l=0.7u
X9 VDD GB GP VDD pfet_06v0 ad=1.7292p pd=8.74u as=1.7292p ps=8.74u w=3.93u l=0.55u
X1 DI DATA VSS ppolyf_u_1k_6p0 r_width=1u r_length=58u
.ends hs_steering_robust
