* Audited RC model assembly from build/highspeed-nrz-robustness-layout/hv-r2/B/readback/hs_steering_robust.ext.
* Original Magic RC preserved in ../unmodified-full-rc/.
* R/MOS unchanged; C counted once with post-simplification allocation weights.
* Coupling remains at original logical nodes; no EM claim.
.subckt hs_steering_robust DATA OUT VDD VSS BIAS DUMMY
X0 VSS.t8 DI.t2 GB.t1 VSS.t7 nfet_06v0 ad=1.1p pd=5.88u as=1.1p ps=5.88u w=2.5u l=0.7u
X1 DI.t0 DATA.t0 VSS.t6 ppolyf_u_1k_6p0 r_width=1u r_length=58u
X2 VX.t1 GB.t2 DUMMY.t0 VSS.t9 nfet_06v0 ad=1.1p pd=5.88u as=1.1p ps=5.88u w=2.5u l=0.7u
X3 VSS.t5 BIAS.t2 OUT.t0 VSS.t4 nfet_03v3 ad=0.88p pd=4.88u as=0.88p ps=4.88u w=2u l=1u
X4 VX.t2 GP.t2 OUT.t1 VSS.t12 nfet_06v0 ad=1.1p pd=5.88u as=1.1p ps=5.88u w=2.5u l=0.7u
X5 VDD.t1 DI.t1 GB.t0 VDD.t0 pfet_06v0 ad=1.7292p pd=8.74u as=1.7292p ps=8.74u w=3.93u l=0.55u
X6 VSS.t1 BIAS.t3 VX.t0 VSS.t0 nfet_03v3 ad=2.5344p pd=12.4u as=2.5344p ps=12.4u w=5.76u l=1u
X7 VSS.t3 BIAS.t0 BIAS.t1 VSS.t2 nfet_03v3 ad=0.88p pd=4.88u as=0.88p ps=4.88u w=2u l=1u
X8 VSS.t11 GB.t4 GP.t0 VSS.t10 nfet_06v0 ad=1.1p pd=5.88u as=1.1p ps=5.88u w=2.5u l=0.7u
X9 VDD.t3 GB.t3 GP.t1 VDD.t2 pfet_06v0 ad=1.7292p pd=8.74u as=1.7292p ps=8.74u w=3.93u l=0.55u
R0 BIAS.n2 BIAS.t3 50.8382
R1 BIAS.n0 BIAS.t0 36.8399
R2 BIAS.n1 BIAS.t2 36.6689
R3 BIAS.n0 BIAS.t1 14.7577
R4 BIAS.n2 BIAS.n1 1.3505
R5 BIAS.n1 BIAS.n0 1.1795
R6 BIAS BIAS.n2 0.0905
R7 DUMMY DUMMY.t0 14.0846
R8 OUT.n0 OUT.t0 19.6265
R9 OUT.n0 OUT.t1 15.1315
R10 OUT OUT.n0 0.0905
R11 DATA DATA.t0 16.4663
R12 VDD.n2 VDD.t0 119.847
R13 VDD.n0 VDD.t2 119.847
R14 VDD.n0 VDD.t3 14.7281
R15 VDD.n1 VDD.t1 14.0452
R16 VDD.n1 VDD.n0 2.01762
R17 VDD.n2 VDD.n1 0.683375
R18 VDD VDD.n2 0.0905
R19 VSS.n31 VSS.n6 3421.53
R20 VSS.n24 VSS.n3 3421.53
R21 VSS.n33 VSS.n32 1488.79
R22 VSS.t10 VSS.n4 1339.23
R23 VSS.n32 VSS.t10 900.301
R24 VSS.n23 VSS.n22 862.535
R25 VSS.n20 VSS.n19 831.545
R26 VSS.n12 VSS.n11 800.899
R27 VSS.n13 VSS.n8 800.557
R28 VSS.n34 VSS.n33 616.194
R29 VSS.n40 VSS.n36 616.194
R30 VSS.n40 VSS.n33 616.194
R31 VSS.n32 VSS.n2 493.247
R32 VSS.n13 VSS.t4 374.454
R33 VSS.t4 VSS.n12 374.454
R34 VSS.n8 VSS.t0 374.454
R35 VSS.t10 VSS.n3 343.464
R36 VSS.t10 VSS.n31 343.464
R37 VSS.n24 VSS.t12 343.464
R38 VSS.t12 VSS.n23 343.464
R39 VSS.n22 VSS.t9 343.464
R40 VSS.n20 VSS.t9 343.464
R41 VSS.n6 VSS.t7 343.464
R42 VSS.t7 VSS.n2 343.464
R43 VSS.t0 VSS.n4 343.464
R44 VSS.n42 VSS.n41 213.851
R45 VSS.n11 VSS.t2 201.73
R46 VSS.n18 VSS.n8 99.9027
R47 VSS.n41 VSS.t6 81.5237
R48 VSS.n35 VSS.n34 71.8966
R49 VSS.n6 VSS.n5 69.8005
R50 VSS.n21 VSS.n20 69.8005
R51 VSS.n25 VSS.n23 69.8005
R52 VSS.n30 VSS.n3 69.8005
R53 VSS.n14 VSS.n12 63.7434
R54 VSS.n42 VSS.n32 44.8973
R55 VSS.n19 VSS.n4 30.9898
R56 VSS.n10 VSS.t3 15.7754
R57 VSS.n9 VSS.t5 15.0419
R58 VSS.n27 VSS.t11 14.5631
R59 VSS.n28 VSS.t8 14.5631
R60 VSS.n11 VSS.n10 14.0401
R61 VSS.n15 VSS.n14 13.6394
R62 VSS.n26 VSS.n25 13.5028
R63 VSS.n5 VSS.n0 13.5028
R64 VSS.n21 VSS.n7 13.5028
R65 VSS.n30 VSS.n29 13.5028
R66 VSS.n16 VSS.t1 13.4572
R67 VSS.n18 VSS.n17 13.2432
R68 VSS.n43 VSS.n1 13.1668
R69 VSS.n39 VSS.n37 12.4264
R70 VSS.n39 VSS.n38 12.4264
R71 VSS.n37 VSS.n1 12.397
R72 VSS.n38 VSS.n1 12.397
R73 VSS.n43 VSS.n42 6.77158
R74 VSS.n27 VSS.n26 2.00075
R75 VSS.n29 VSS.n28 2.00075
R76 VSS.n17 VSS.n7 1.3505
R77 VSS.n26 VSS.n7 1.3505
R78 VSS.n38 VSS.n36 1.3005
R79 VSS.n37 VSS.n33 1.3005
R80 VSS.n36 VSS.n35 1.1469
R81 VSS.n14 VSS.n13 0.743357
R82 VSS.n15 VSS.n9 0.734
R83 VSS.n17 VSS.n16 0.734
R84 VSS.n28 VSS.n0 0.70025
R85 VSS.n29 VSS.n27 0.70025
R86 VSS.n16 VSS.n15 0.617
R87 VSS.n10 VSS.n9 0.617
R88 VSS.n25 VSS.n24 0.578278
R89 VSS.n31 VSS.n30 0.578278
R90 VSS.n5 VSS.n2 0.578278
R91 VSS.n22 VSS.n21 0.578278
R92 VSS.n19 VSS.n18 0.347167
R93 VSS VSS.n43 0.248
R94 VSS.n35 VSS.t6 0.15268
R95 VSS VSS.n0 0.0905
R96 VSS.n41 VSS.n40 0.041125
R97 VSS.n40 VSS.n39 0.041125
R98 VSS.n34 VSS.n1 0.041125
R99 VX.n0 VX.t1 13.142
R100 VX.n1 VX.t2 13.142
R101 VX.n0 VX.t0 13.0779
R102 VX.n1 VX.n0 1.3505
R103 VX VX.n1 0.068
R104 GP.n0 GP.t2 48.6459
R105 GP.n3 GP.n2 12.771
R106 GP.n0 GP.t1 12.6241
R107 GP.n3 GP.n0 1.36738
R108 GP.n2 GP.t0 0.6557
R109 GP.n2 GP.n1 0.4541
R110 GP GP.n3 0.068
R111 GB.n0 GB.t3 62.0963
R112 GB.n0 GB.t2 50.1597
R113 GB.n1 GB.t4 47.4597
R114 GB.n5 GB.n4 13.0552
R115 GB.n2 GB.t0 12.9083
R116 GB.n2 GB.n1 1.47087
R117 GB.n5 GB.n2 1.36738
R118 GB.n1 GB.n0 1.3505
R119 GB.n4 GB.t1 0.6557
R120 GB.n4 GB.n3 0.4541
R121 GB GB.n5 0.068
R122 DI.n0 DI.t1 51.0678
R123 DI.n0 DI.t2 44.4281
R124 DI DI.t0 14.958
R125 DI.t0 DI.n1 5.98411
R126 DI DI.n0 0.068
C0 BIAS VSS 1.526923592738372e-17
C1 BIAS.n0 VSS 1.3329925522230346e-15
C2 BIAS.n1 VSS 1.000447125440656e-15
C3 BIAS.n2 VSS 1.0802107918541058e-15
C4 BIAS.t0 VSS 6.0278054902424779e-16
C5 BIAS.t1 VSS 4.5752440781848453e-16
C6 BIAS.t2 VSS 5.9925619832135033e-16
C7 BIAS.t3 VSS 9.6565913939073803e-16
C8 DATA VSS 5.1379399999999998e-16
C9 DI VSS 5.2850763354541121e-16
C10 DI.n0 VSS 6.6474984037891113e-16
C11 DI.n1 VSS 2.2119677496949634e-17
C12 DI.t0 VSS 1.4223435687369727e-16
C13 DI.t1 VSS 3.8943809614696759e-16
C14 DI.t2 VSS 4.0874039555806332e-16
C15 DUMMY VSS 3.5341166490833555e-16
C16 DUMMY.t0 VSS 3.9815433509166468e-16
C17 GB VSS 1.351598931754951e-17
C18 GB.n0 VSS 1.6173279826742568e-15
C19 GB.n1 VSS 7.4553630411229527e-16
C20 GB.n2 VSS 4.9834854629625917e-16
C21 GB.n3 VSS 2.1722182653644226e-17
C22 GB.n4 VSS 3.096788901278844e-16
C23 GB.n5 VSS 3.7392163595883402e-16
C24 GB.t0 VSS 4.5123623267943519e-16
C25 GB.t1 VSS 3.1376357165380211e-17
C26 GB.t2 VSS 3.7809476816742161e-16
C27 GB.t3 VSS 3.2471115614818581e-16
C28 GB.t4 VSS 3.3747995469885375e-16
C29 GP VSS 1.2859622697548757e-17
C30 GP.n0 VSS 1.0167397814037248e-15
C31 GP.n1 VSS 2.0667307385436584e-17
C32 GP.n2 VSS 2.7518360186520758e-16
C33 GP.n3 VSS 3.333340528078255e-16
C34 GP.t0 VSS 2.9852706872184833e-17
C35 GP.t1 VSS 4.0955492179119252e-16
C36 GP.t2 VSS 3.3197800517687966e-16
C37 OUT VSS 1.6466347686973828e-17
C38 OUT.n0 VSS 1.9087187534759115e-15
C39 OUT.t0 VSS 7.9796299067464016e-16
C40 OUT.t1 VSS 6.3552190816247461e-16
C41 VDD VSS 1.1719458266872449e-17
C42 VDD.n0 VSS 2.9316233147123788e-15
C43 VDD.n1 VSS 5.8576332161373575e-16
C44 VDD.n2 VSS 2.3540887466676726e-15
C45 VDD.t0 VSS 1.4181918088136746e-15
C46 VDD.t1 VSS 5.41053456799213e-16
C47 VDD.t2 VSS 1.4181918088136746e-15
C48 VDD.t3 VSS 5.609980843127776e-16
C49 VX VSS 1.5914451589779977e-17
C50 VX.n0 VSS 8.3785452440449232e-16
C51 VX.n1 VSS 4.00030577413743e-16
C52 VX.t0 VSS 6.5572590810801272e-16
C53 VX.t1 VSS 3.6202226924198612e-16
C54 VX.t2 VSS 3.6202226924198612e-16
C55 DUMMY OUT 2.6675400000000002e-19
C56 VX BIAS 2.5549600000000004e-16
C57 BIAS OUT 2.1191100000000002e-16
C58 DUMMY BIAS 7.9810900000000005e-19
C59 GB GP 9.4624600000000007e-16
C60 VDD GB 1.7549500000000002e-15
C61 VX GB 2.9122800000000002e-16
C62 GB OUT 6.5083600000000007e-17
C63 VDD GP 1.0070900000000002e-15
C64 DI GB 1.6138800000000001e-16
C65 DUMMY GB 2.0769700000000003e-16
C66 VX GP 1.5857600000000001e-16
C67 VX VDD 2.9333199999999999e-19
C68 GP OUT 1.7895500000000002e-16
C69 VDD OUT 6.5634800000000003e-18
C70 DI GP 1.13075e-19
C71 VDD DI 4.64497e-16
C72 VX OUT 2.8288800000000001e-16
C73 BIAS GB 9.2657300000000016e-17
C74 DUMMY GP 8.2815100000000015e-18
C75 VX DUMMY 3.3480599999999999e-16
.ends hs_steering_robust
