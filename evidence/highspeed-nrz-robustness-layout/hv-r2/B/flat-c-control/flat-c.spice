* NGSPICE file created from hs_steering_robust.ext - technology: gf180mcuD

X0 VSS DI GB VSS nfet_06v0 ad=1.1p pd=5.88u as=1.1p ps=5.88u w=2.5u l=0.7u
X1 DI DATA VSS ppolyf_u_1k_6p0 r_width=1u r_length=58u
X2 VX GB DUMMY VSS nfet_06v0 ad=1.1p pd=5.88u as=1.1p ps=5.88u w=2.5u l=0.7u
X3 VSS BIAS OUT VSS nfet_03v3 ad=0.88p pd=4.88u as=0.88p ps=4.88u w=2u l=1u
X4 VX GP OUT VSS nfet_06v0 ad=1.1p pd=5.88u as=1.1p ps=5.88u w=2.5u l=0.7u
X5 VDD DI GB VDD pfet_06v0 ad=1.7292p pd=8.74u as=1.7292p ps=8.74u w=3.93u l=0.55u
X6 VSS BIAS VX VSS nfet_03v3 ad=2.5344p pd=12.4u as=2.5344p ps=12.4u w=5.76u l=1u
X7 VSS BIAS BIAS VSS nfet_03v3 ad=0.88p pd=4.88u as=0.88p ps=4.88u w=2u l=1u
X8 VSS GB GP VSS nfet_06v0 ad=1.1p pd=5.88u as=1.1p ps=5.88u w=2.5u l=0.7u
X9 VDD GB GP VDD pfet_06v0 ad=1.7292p pd=8.74u as=1.7292p ps=8.74u w=3.93u l=0.55u
C0 OUT DUMMY 0
C1 GP VDD 1.00709f
C2 GB VDD 1.75495f
C3 GP VX 0.15858f
C4 VX BIAS 0.2555f
C5 VDD OUT 0.00656f
C6 GB VX 0.29123f
C7 DI VDD 0.4645f
C8 VX DUMMY 0.33481f
C9 GB GP 0.94625f
C10 VX OUT 0.28289f
C11 GB BIAS 0.09266f
C12 GP DUMMY 0.00828f
C13 DUMMY BIAS 0
C14 GB DUMMY 0.2077f
C15 GP OUT 0.17896f
C16 DI GP 0
C17 OUT BIAS 0.21191f
C18 GB OUT 0.06508f
C19 VX VDD 0
C20 DI GB 0.16139f
C21 BIAS VSS 6.05414f
C22 DUMMY VSS 0.75157f
C23 OUT VSS 3.35867f
C24 DATA VSS 0.51379f
C25 VDD VSS 9.82163f
C26 VX VSS 2.63357f ; **FLOATING
C27 GP VSS 2.43017f ; **FLOATING
C28 GB VSS 5.10295f ; **FLOATING
C29 DI VSS 2.15579f ; **FLOATING
