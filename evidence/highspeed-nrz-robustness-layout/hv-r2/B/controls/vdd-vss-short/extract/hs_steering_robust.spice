* NGSPICE file created from hs_steering_robust.ext - technology: gf180mcuD

.subckt hs_steering_robust DATA OUT VSS BIAS DUMMY
X0 VSS a_n1100_4414# a_642_3750# VSS nfet_06v0 ad=1.1p pd=5.88u as=1.1p ps=5.88u w=2.5u l=0.7u
X1 a_n1100_4414# DATA VSS ppolyf_u_1k_6p0 r_width=1u r_length=58u
X2 a_5670_3750# a_642_3750# DUMMY VSS nfet_06v0 ad=1.1p pd=5.88u as=1.1p ps=5.88u w=2.5u l=0.7u
X3 VSS BIAS OUT VSS nfet_03v3 ad=0.88p pd=4.88u as=0.88p ps=4.88u w=2u l=1u
X4 a_5670_3750# a_3042_3750# OUT VSS nfet_06v0 ad=1.1p pd=5.88u as=1.1p ps=5.88u w=2.5u l=0.7u
X5 VSS a_n1100_4414# a_642_3750# VSS pfet_06v0 ad=1.7292p pd=8.74u as=1.7292p ps=8.74u w=3.93u l=0.55u
X6 VSS BIAS a_5670_3750# VSS nfet_03v3 ad=2.5344p pd=12.4u as=2.5344p ps=12.4u w=5.76u l=1u
X7 VSS BIAS BIAS VSS nfet_03v3 ad=0.88p pd=4.88u as=0.88p ps=4.88u w=2u l=1u
X8 VSS a_642_3750# a_3042_3750# VSS nfet_06v0 ad=1.1p pd=5.88u as=1.1p ps=5.88u w=2.5u l=0.7u
X9 VSS a_642_3750# a_3042_3750# VSS pfet_06v0 ad=1.7292p pd=8.74u as=1.7292p ps=8.74u w=3.93u l=0.55u
.ends
