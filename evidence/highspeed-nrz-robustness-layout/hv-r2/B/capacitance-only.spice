* Explicit control derived from full raw RC; original RC retained.
.subckt hs_steering_robust DATA OUT VDD VSS BIAS DUMMY
X0 VSS DI GB VSS nfet_06v0 ad=1.1p pd=5.88u as=1.1p ps=5.88u w=2.5u l=0.7u
X2 VX GB DUMMY VSS nfet_06v0 ad=1.1p pd=5.88u as=1.1p ps=5.88u w=2.5u l=0.7u
X3 VSS BIAS OUT VSS nfet_03v3 ad=0.88p pd=4.88u as=0.88p ps=4.88u w=2u l=1u
X4 VX GP OUT VSS nfet_06v0 ad=1.1p pd=5.88u as=1.1p ps=5.88u w=2.5u l=0.7u
X5 VDD DI GB VDD pfet_06v0 ad=1.7292p pd=8.74u as=1.7292p ps=8.74u w=3.93u l=0.55u
X6 VSS BIAS VX VSS nfet_03v3 ad=2.5344p pd=12.4u as=2.5344p ps=12.4u w=5.76u l=1u
X7 VSS BIAS BIAS VSS nfet_03v3 ad=0.88p pd=4.88u as=0.88p ps=4.88u w=2u l=1u
X8 VSS GB GP VSS nfet_06v0 ad=1.1p pd=5.88u as=1.1p ps=5.88u w=2.5u l=0.7u
X9 VDD GB GP VDD pfet_06v0 ad=1.7292p pd=8.74u as=1.7292p ps=8.74u w=3.93u l=0.55u
X1 DI DATA VSS ppolyf_u_1k_6p0 r_width=1u r_length=58u
C0 BIAS VSS 1.52692359274e-17
C1 BIAS VSS 1.33299255222e-15
C2 BIAS VSS 1.00044712544e-15
C3 BIAS VSS 1.08021079185e-15
C4 BIAS VSS 6.02780549024e-16
C5 BIAS VSS 4.57524407818e-16
C6 BIAS VSS 5.99256198321e-16
C7 BIAS VSS 9.65659139391e-16
C8 DATA VSS 5.13794e-16
C9 DI VSS 5.28507633545e-16
C10 DI VSS 6.64749840379e-16
C11 DI VSS 2.21196774969e-17
C12 DI VSS 1.42234356874e-16
C13 DI VSS 3.89438096147e-16
C14 DI VSS 4.08740395558e-16
C15 DUMMY VSS 3.53411664908e-16
C16 DUMMY VSS 3.98154335092e-16
C17 GB VSS 1.35159893175e-17
C18 GB VSS 1.61732798267e-15
C19 GB VSS 7.45536304112e-16
C20 GB VSS 4.98348546296e-16
C21 GB VSS 2.17221826536e-17
C22 GB VSS 3.09678890128e-16
C23 GB VSS 3.73921635959e-16
C24 GB VSS 4.51236232679e-16
C25 GB VSS 3.13763571654e-17
C26 GB VSS 3.78094768167e-16
C27 GB VSS 3.24711156148e-16
C28 GB VSS 3.37479954699e-16
C29 GP VSS 1.28596226975e-17
C30 GP VSS 1.0167397814e-15
C31 GP VSS 2.06673073854e-17
C32 GP VSS 2.75183601865e-16
C33 GP VSS 3.33334052808e-16
C34 GP VSS 2.98527068722e-17
C35 GP VSS 4.09554921791e-16
C36 GP VSS 3.31978005177e-16
C37 OUT VSS 1.6466347687e-17
C38 OUT VSS 1.90871875348e-15
C39 OUT VSS 7.97962990675e-16
C40 OUT VSS 6.35521908162e-16
C41 VDD VSS 1.17194582669e-17
C42 VDD VSS 2.93162331471e-15
C43 VDD VSS 5.85763321614e-16
C44 VDD VSS 2.35408874667e-15
C45 VDD VSS 1.41819180881e-15
C46 VDD VSS 5.41053456799e-16
C47 VDD VSS 1.41819180881e-15
C48 VDD VSS 5.60998084313e-16
C49 VX VSS 1.59144515898e-17
C50 VX VSS 8.37854524404e-16
C51 VX VSS 4.00030577414e-16
C52 VX VSS 6.55725908108e-16
C53 VX VSS 3.62022269242e-16
C54 VX VSS 3.62022269242e-16
C55 DUMMY OUT 2.66754e-19
C56 VX BIAS 2.55496e-16
C57 BIAS OUT 2.11911e-16
C58 DUMMY BIAS 7.98109e-19
C59 GB GP 9.46246e-16
C60 VDD GB 1.75495e-15
C61 VX GB 2.91228e-16
C62 GB OUT 6.50836e-17
C63 VDD GP 1.00709e-15
C64 DI GB 1.61388e-16
C65 DUMMY GB 2.07697e-16
C66 VX GP 1.58576e-16
C67 VX VDD 2.93332e-19
C68 GP OUT 1.78955e-16
C69 VDD OUT 6.56348e-18
C70 DI GP 1.13075e-19
C71 VDD DI 4.64497e-16
C72 VX OUT 2.82888e-16
C73 BIAS GB 9.26573e-17
C74 DUMMY GP 8.28151e-18
C75 VX DUMMY 3.34806e-16
.ends hs_steering_robust
