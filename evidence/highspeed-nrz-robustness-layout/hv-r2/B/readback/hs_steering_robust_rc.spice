* NGSPICE file created from hs_steering_robust.ext - technology: gf180mcuD

.subckt hs_steering_robust DATA OUT VDD VSS BIAS DUMMY
X0 VSS.t8 DI GB.t1 VSS.t7 nfet_06v0 ad=1.1p pd=5.88u as=1.1p ps=5.88u w=2.5u l=0.7u
X1 DI DATA.t0 VSS.t6 ppolyf_u_1k_6p0 r_width=1u r_length=58u
X2 VX.t1 GB.t2 DUMMY.t0 VSS.t9 nfet_06v0 ad=1.1p pd=5.88u as=1.1p ps=5.88u w=2.5u l=0.7u
X3 VSS.t5 BIAS.t2 OUT.t0 VSS.t4 nfet_03v3 ad=0.88p pd=4.88u as=0.88p ps=4.88u w=2u l=1u
X4 VX.t2 GP.t2 OUT.t1 VSS.t10 nfet_06v0 ad=1.1p pd=5.88u as=1.1p ps=5.88u w=2.5u l=0.7u
X5 VDD.t1 DI GB.t0 VDD.t0 pfet_06v0 ad=1.7292p pd=8.74u as=1.7292p ps=8.74u w=3.93u l=0.55u
X6 VSS.t1 BIAS.t3 VX.t0 VSS.t0 nfet_03v3 ad=2.5344p pd=12.4u as=2.5344p ps=12.4u w=5.76u l=1u
X7 VSS.t3 BIAS.t0 BIAS.t1 VSS.t2 nfet_03v3 ad=0.88p pd=4.88u as=0.88p ps=4.88u w=2u l=1u
X8 VSS.t12 GB.t4 GP.t1 VSS.t11 nfet_06v0 ad=1.1p pd=5.88u as=1.1p ps=5.88u w=2.5u l=0.7u
X9 VDD.t3 GB.t3 GP.t0 VDD.t2 pfet_06v0 ad=1.7292p pd=8.74u as=1.7292p ps=8.74u w=3.93u l=0.55u
R0 BIAS.n2 BIAS.t3 50.8382
R1 BIAS.n0 BIAS.t0 36.8399
R2 BIAS.n1 BIAS.t2 36.6689
R3 BIAS.n0 BIAS.t1 14.7577
R4 BIAS.n2 BIAS.n1 1.3505
R5 BIAS.n1 BIAS.n0 1.1795
R6 BIAS BIAS.n2 0.0905
R7 DUMMY DUMMY.t0 14.0846
R8 OUT.n0 OUT.t0 19.6265
R9 OUT.n0 OUT.t1 15.1315
R10 OUT OUT.n0 0.0905
R11 DATA DATA.t0 16.4663
R12 VDD.n2 VDD.t0 119.847
R13 VDD.n0 VDD.t2 119.847
R14 VDD.n0 VDD.t3 14.7281
R15 VDD.n1 VDD.t1 14.0452
R16 VDD.n1 VDD.n0 2.01762
R17 VDD.n2 VDD.n1 0.683375
R18 VDD VDD.n2 0.0905
R19 VSS.n31 VSS.n6 3421.53
R20 VSS.n24 VSS.n3 3421.53
R21 VSS.n33 VSS.n32 1488.79
R22 VSS.t11 VSS.n4 1339.23
R23 VSS.n32 VSS.t11 900.301
R24 VSS.n23 VSS.n22 862.535
R25 VSS.n20 VSS.n19 831.545
R26 VSS.n12 VSS.n11 800.899
R27 VSS.n13 VSS.n8 800.557
R28 VSS.n34 VSS.n33 616.194
R29 VSS.n40 VSS.n36 616.194
R30 VSS.n40 VSS.n33 616.194
R31 VSS.n32 VSS.n2 493.247
R32 VSS.n13 VSS.t4 374.454
R33 VSS.t4 VSS.n12 374.454
R34 VSS.n8 VSS.t0 374.454
R35 VSS.t11 VSS.n3 343.464
R36 VSS.t11 VSS.n31 343.464
R37 VSS.n24 VSS.t10 343.464
R38 VSS.t10 VSS.n23 343.464
R39 VSS.n22 VSS.t9 343.464
R40 VSS.n20 VSS.t9 343.464
R41 VSS.n6 VSS.t7 343.464
R42 VSS.t7 VSS.n2 343.464
R43 VSS.t0 VSS.n4 343.464
R44 VSS.n42 VSS.n41 213.851
R45 VSS.n11 VSS.t2 201.73
R46 VSS.n18 VSS.n8 99.9027
R47 VSS.n41 VSS.t6 81.5237
R48 VSS.n35 VSS.n34 71.8966
R49 VSS.n6 VSS.n5 69.8005
R50 VSS.n21 VSS.n20 69.8005
R51 VSS.n25 VSS.n23 69.8005
R52 VSS.n30 VSS.n3 69.8005
R53 VSS.n14 VSS.n12 63.7434
R54 VSS.n42 VSS.n32 44.8973
R55 VSS.n19 VSS.n4 30.9898
R56 VSS.n10 VSS.t3 15.7754
R57 VSS.n9 VSS.t5 15.0419
R58 VSS.n27 VSS.t12 14.5631
R59 VSS.n28 VSS.t8 14.5631
R60 VSS.n11 VSS.n10 14.0401
R61 VSS.n15 VSS.n14 13.6394
R62 VSS.n26 VSS.n25 13.5028
R63 VSS.n5 VSS.n0 13.5028
R64 VSS.n21 VSS.n7 13.5028
R65 VSS.n30 VSS.n29 13.5028
R66 VSS.n16 VSS.t1 13.4572
R67 VSS.n18 VSS.n17 13.2432
R68 VSS.n43 VSS.n1 13.1668
R69 VSS.n39 VSS.n37 12.4264
R70 VSS.n39 VSS.n38 12.4264
R71 VSS.n37 VSS.n1 12.397
R72 VSS.n38 VSS.n1 12.397
R73 VSS.n43 VSS.n42 6.77158
R74 VSS.n27 VSS.n26 2.00075
R75 VSS.n29 VSS.n28 2.00075
R76 VSS.n17 VSS.n7 1.3505
R77 VSS.n26 VSS.n7 1.3505
R78 VSS.n38 VSS.n36 1.3005
R79 VSS.n37 VSS.n33 1.3005
R80 VSS.n36 VSS.n35 1.1469
R81 VSS.n14 VSS.n13 0.743357
R82 VSS.n15 VSS.n9 0.734
R83 VSS.n17 VSS.n16 0.734
R84 VSS.n28 VSS.n0 0.70025
R85 VSS.n29 VSS.n27 0.70025
R86 VSS.n16 VSS.n15 0.617
R87 VSS.n10 VSS.n9 0.617
R88 VSS.n25 VSS.n24 0.578278
R89 VSS.n31 VSS.n30 0.578278
R90 VSS.n5 VSS.n2 0.578278
R91 VSS.n22 VSS.n21 0.578278
R92 VSS.n19 VSS.n18 0.347167
R93 VSS VSS.n43 0.248
R94 VSS.n35 VSS.t6 0.15268
R95 VSS VSS.n0 0.0905
R96 VSS.n41 VSS.n40 0.041125
R97 VSS.n40 VSS.n39 0.041125
R98 VSS.n34 VSS.n1 0.041125
R99 VX.n1 VX.t2 13.142
R100 VX.n0 VX.t1 13.142
R101 VX.n0 VX.t0 13.0779
R102 VX.n1 VX.n0 1.3505
R103 VX VX.n1 0.068
R104 GP.n0 GP.t2 48.6459
R105 GP.n1 GP.t1 13.4262
R106 GP.n0 GP.t0 12.6241
R107 GP.n1 GP.n0 1.36738
R108 GP GP.n1 0.068
R109 GB.n0 GB.t3 62.0963
R110 GB.n0 GB.t2 50.1597
R111 GB.n1 GB.t4 47.4597
R112 GB.n3 GB.t1 13.7104
R113 GB.n2 GB.t0 12.9083
R114 GB.n2 GB.n1 1.47087
R115 GB.n3 GB.n2 1.36738
R116 GB.n1 GB.n0 1.3505
R117 GB GB.n3 0.068
C0 DUMMY BIAS 0
C1 GB DUMMY 0.2077f
C2 GP OUT 0.17896f
C3 DI GP 0
C4 OUT BIAS 0.21191f
C5 GB OUT 0.06508f
C6 VX VDD 0
C7 DI GB 0.16139f
C8 OUT DUMMY 0
C9 GP VDD 1.00709f
C10 GB VDD 1.75495f
C11 GP VX 0.15858f
C12 VX BIAS 0.2555f
C13 VDD OUT 0.00656f
C14 GB VX 0.29123f
C15 DI VDD 0.4645f
C16 VX DUMMY 0.33481f
C17 GB GP 0.94625f
C18 VX OUT 0.28289f
C19 GB BIAS 0.09266f
C20 GP DUMMY 0.00828f
C21 BIAS VSS 6.05555f
C22 DUMMY VSS 1.01106f
C23 OUT VSS 3.36233f
C24 DATA VSS 0.51379f
C25 VDD VSS 9.82549f
C26 VX VSS 2.64157f
C27 GP VSS 2.44234f
C28 GB VSS 5.11227f
C29 GB.n0 VSS 1.11539f
C30 GB.n1 VSS 0.51416f
C31 GB.t0 VSS 0.3112f
C32 GB.n2 VSS 0.34369f
C33 GB.t1 VSS 1.31716f
C34 GB.n3 VSS 0.2688f
C35 GP.t0 VSS 0.49946f
C36 GP.n0 VSS 0.96197f
C37 GP.t1 VSS 0.41087f
C38 GP.n1 VSS 0.32904f
C39 VX.t0 VSS 0.37421f
C40 VX.t1 VSS 0.31228f
C41 VX.n0 VSS 0.421f
C42 VX.t2 VSS 0.33895f
C43 VX.n1 VSS 0.201f
C44 VSS.t5 VSS 0.02776f
C45 VSS.t3 VSS 0.02792f
C46 VSS.t1 VSS 0.04473f
C47 VSS.t12 VSS 0.11637f
C48 VSS.t8 VSS 1.0779f
C49 VDD.t3 VSS 0.29666f
C50 VDD.t2 VSS 0.46688f
C51 VDD.n0 VSS 0.96512f
C52 VDD.t1 VSS 0.17812f
C53 VDD.n1 VSS 0.19284f
C54 VDD.t0 VSS 0.46688f
C55 VDD.n2 VSS 0.77499f
C56 OUT.t0 VSS 0.20492f
C57 OUT.t1 VSS 0.29814f
C58 OUT.n0 VSS 0.42376f
C59 DUMMY.t0 VSS 0.42273f
C60 BIAS.t1 VSS 0.07031f
C61 BIAS.n0 VSS 0.12349f
C62 BIAS.n1 VSS 0.09268f
C63 BIAS.n2 VSS 0.10007f
.ends
