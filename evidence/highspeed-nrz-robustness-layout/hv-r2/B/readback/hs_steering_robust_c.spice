* NGSPICE file created from hs_steering_robust.ext - technology: gf180mcuD

.subckt hs_steering_robust DATA OUT VDD VSS BIAS DUMMY
X0 VSS DI GB VSS nfet_06v0 ad=1.1p pd=5.88u as=1.1p ps=5.88u w=2.5u l=0.7u
X1 DI DATA VSS ppolyf_u_1k_6p0 r_width=1u r_length=58u
X2 VX GB DUMMY VSS nfet_06v0 ad=1.1p pd=5.88u as=1.1p ps=5.88u w=2.5u l=0.7u
X3 VSS BIAS OUT VSS nfet_03v3 ad=0.88p pd=4.88u as=0.88p ps=4.88u w=2u l=1u
X4 VX GP OUT VSS nfet_06v0 ad=1.1p pd=5.88u as=1.1p ps=5.88u w=2.5u l=0.7u
X5 VDD DI GB VDD pfet_06v0 ad=1.7292p pd=8.74u as=1.7292p ps=8.74u w=3.93u l=0.55u
X6 VSS BIAS VX VSS nfet_03v3 ad=2.5344p pd=12.4u as=2.5344p ps=12.4u w=5.76u l=1u
X7 VSS BIAS BIAS VSS nfet_03v3 ad=0.88p pd=4.88u as=0.88p ps=4.88u w=2u l=1u
X8 VSS GB GP VSS nfet_06v0 ad=1.1p pd=5.88u as=1.1p ps=5.88u w=2.5u l=0.7u
X9 VDD GB GP VDD pfet_06v0 ad=1.7292p pd=8.74u as=1.7292p ps=8.74u w=3.93u l=0.55u
C0 VX DUMMY 0.33481f
C1 GB GP 0.94625f
C2 VX OUT 0.28289f
C3 GB BIAS 0.09266f
C4 GP DUMMY 0.00828f
C5 DUMMY BIAS 0
C6 GB DUMMY 0.2077f
C7 GP OUT 0.17896f
C8 DI GP 0
C9 OUT BIAS 0.21191f
C10 GB OUT 0.06508f
C11 VX VDD 0
C12 DI GB 0.16139f
C13 OUT DUMMY 0
C14 GP VDD 1.00709f
C15 GB VDD 1.75495f
C16 GP VX 0.15858f
C17 VX BIAS 0.2555f
C18 VDD OUT 0.00656f
C19 GB VX 0.29123f
C20 DI VDD 0.4645f
C21 DUMMY VSS 3.84199f
C22 OUT VSS 7.60083f
C23 DATA VSS 0.51379f
C24 VDD VSS 9.82163f
C25 VX VSS 6.93908f
.ends
