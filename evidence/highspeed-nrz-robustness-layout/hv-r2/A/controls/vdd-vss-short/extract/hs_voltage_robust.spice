* NGSPICE file created from hs_voltage_robust.ext - technology: gf180mcuD

.subckt hs_voltage_robust DATA OUT VH VL VSS
X0 VSS a_n1100_4414# a_642_3750# VSS nfet_06v0 ad=1.1p pd=5.88u as=1.1p ps=5.88u w=2.5u l=0.7u
X1 a_n1100_4414# DATA VSS ppolyf_u_1k_6p0 r_width=1u r_length=48u
X2 VH a_3042_3000# OUT VH pfet_06v0 ad=6.9168p pd=32.32u as=6.9168p ps=32.32u w=15.72u l=0.55u
X3 VSS a_642_3750# a_3042_3000# VSS pfet_06v0 ad=6.9168p pd=32.32u as=6.9168p ps=32.32u w=15.72u l=0.55u
X4 VL a_3042_3000# OUT VSS nfet_06v0 ad=4.4p pd=20.88u as=4.4p ps=20.88u w=10u l=0.7u
X5 VSS a_642_3750# a_3042_3000# VSS nfet_06v0 ad=4.4p pd=20.88u as=4.4p ps=20.88u w=10u l=0.7u
X6 VSS a_n1100_4414# a_642_3750# VSS pfet_06v0 ad=1.7292p pd=8.74u as=1.7292p ps=8.74u w=3.93u l=0.55u
.ends
