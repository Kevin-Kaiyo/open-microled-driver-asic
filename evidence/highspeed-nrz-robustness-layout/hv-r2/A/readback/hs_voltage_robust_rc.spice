* NGSPICE file created from hs_voltage_robust.ext - technology: gf180mcuD

.subckt hs_voltage_robust DATA OUT VDD VH VL VSS
X0 VSS.t2 DI N1.t1 VSS.t1 nfet_06v0 ad=1.1p pd=5.88u as=1.1p ps=5.88u w=2.5u l=0.7u
X1 DI DATA.t0 VSS.t0 ppolyf_u_1k_6p0 r_width=1u r_length=48u
X2 VH.t1 CTRL.t2 OUT.t0 VH.t0 pfet_06v0 ad=6.9168p pd=32.32u as=6.9168p ps=32.32u w=15.72u l=0.55u
X3 VDD.t3 N1.t2 CTRL.t0 VDD.t2 pfet_06v0 ad=6.9168p pd=32.32u as=6.9168p ps=32.32u w=15.72u l=0.55u
X4 VL.t0 CTRL.t3 OUT.t1 VSS.t5 nfet_06v0 ad=4.4p pd=20.88u as=4.4p ps=20.88u w=10u l=0.7u
X5 VSS.t4 N1.t3 CTRL.t1 VSS.t3 nfet_06v0 ad=4.4p pd=20.88u as=4.4p ps=20.88u w=10u l=0.7u
X6 VDD.t1 DI N1.t0 VDD.t0 pfet_06v0 ad=1.7292p pd=8.74u as=1.7292p ps=8.74u w=3.93u l=0.55u
R0 VL VL.t0 12.9175
R1 OUT.n0 OUT.t0 14.8565
R2 OUT.n0 OUT.t1 13.6801
R3 OUT OUT.n0 0.0905
R4 DATA DATA.t0 16.4663
R5 VH.n0 VH.t0 65.8038
R6 VH.n0 VH.t1 13.6041
R7 VH VH.n0 0.0905
R8 VDD.n2 VDD.t0 119.847
R9 VDD.n0 VDD.t2 66.088
R10 VDD.n1 VDD.t1 14.0452
R11 VDD.n0 VDD.t3 13.8883
R12 VDD.n1 VDD.n0 2.01762
R13 VDD.n2 VDD.n1 0.683375
R14 VDD VDD.n2 0.0905
R15 VSS.n7 VSS.n6 4902.58
R16 VSS.t5 VSS.n2 1764.57
R17 VSS.n11 VSS.n10 1460.95
R18 VSS.n10 VSS.n6 1278.23
R19 VSS.n10 VSS.n2 702.173
R20 VSS.n20 VSS.n2 561.606
R21 VSS.n18 VSS.n14 518.972
R22 VSS.n18 VSS.n11 518.972
R23 VSS.n12 VSS.n11 518.972
R24 VSS.n10 VSS.n9 484.017
R25 VSS.n10 VSS.t3 412.728
R26 VSS.n7 VSS.t1 337.038
R27 VSS.n9 VSS.t1 337.038
R28 VSS.n20 VSS.n19 300.741
R29 VSS.n3 VSS.t5 157.298
R30 VSS.n19 VSS.t0 114.647
R31 VSS.n13 VSS.n12 93.7442
R32 VSS.n8 VSS.n7 69.8005
R33 VSS.n4 VSS.t2 13.9946
R34 VSS.n8 VSS.n0 12.9343
R35 VSS.n6 VSS.n5 12.7732
R36 VSS.n21 VSS.n1 12.551
R37 VSS.n3 VSS.t4 12.5432
R38 VSS.n17 VSS.n15 10.4698
R39 VSS.n17 VSS.n16 10.4698
R40 VSS.n16 VSS.n1 10.4405
R41 VSS.n15 VSS.n1 10.4405
R42 VSS.n21 VSS.n20 6.5462
R43 VSS.n5 VSS.n4 2.00075
R44 VSS.n16 VSS.n14 1.3005
R45 VSS.n15 VSS.n11 1.3005
R46 VSS.n14 VSS.n13 1.06352
R47 VSS.n5 VSS.n3 0.70025
R48 VSS.n4 VSS.n0 0.70025
R49 VSS.n9 VSS.n8 0.578278
R50 VSS VSS.n21 0.248
R51 VSS.n13 VSS.t0 0.235822
R52 VSS VSS.n0 0.0905
R53 VSS.n19 VSS.n18 0.0490981
R54 VSS.n18 VSS.n17 0.0490981
R55 VSS.n12 VSS.n1 0.0490981
R56 CTRL.n0 CTRL.t2 142.802
R57 CTRL.n0 CTRL.t3 87.1708
R58 CTRL.n2 CTRL.t1 11.9748
R59 CTRL.n1 CTRL.t0 11.7844
R60 CTRL.n1 CTRL.n0 1.47087
R61 CTRL.n2 CTRL.n1 1.36738
R62 CTRL CTRL.n2 0.068
R63 N1.n0 N1.t2 143.085
R64 N1.n0 N1.t3 87.455
R65 N1.n2 N1.t1 13.7104
R66 N1.n1 N1.t0 12.9083
R67 N1.n1 N1.n0 1.47087
R68 N1.n2 N1.n1 1.36738
R69 N1 N1.n2 0.068
C0 VDD OUT 0.01927f
C1 N1 CTRL 1.11343f
C2 DI VDD 0.4645f
C3 CTRL VL 0.37065f
C4 VDD VH 0
C5 CTRL OUT 0.79458f
C6 N1 VL 0
C7 DI CTRL 0.00109f
C8 N1 OUT 0.01253f
C9 DI N1 0.16513f
C10 OUT VL 0.59795f
C11 CTRL VH 0.99581f
C12 CTRL VDD 2.2884f
C13 VH VL 0.12573f
C14 N1 VDD 2.00329f
C15 VDD VL 0
C16 VH OUT 2.38453f
C17 VL VSS 1.24527f
C18 OUT VSS 1.90418f
C19 DATA VSS 0.51379f
C20 VH VSS 9.17981f
C21 VDD VSS 14.62158f
C22 CTRL VSS 4.05965f
C23 N1 VSS 4.39187f
C24 N1.n0 VSS 1.29226f
C25 N1.t0 VSS 0.28132f
C26 N1.n1 VSS 0.3107f
C27 N1.t1 VSS 1.28991f
C28 N1.n2 VSS 0.24299f
C29 CTRL.n0 VSS 1.74437f
C30 CTRL.t0 VSS 1.30338f
C31 CTRL.n1 VSS 0.40472f
C32 CTRL.t1 VSS 0.95229f
C33 CTRL.n2 VSS 0.30213f
C34 VSS.t4 VSS 0.22354f
C35 VSS.t2 VSS 1.07361f
C36 VDD.t3 VSS 0.66098f
C37 VDD.t2 VSS 1.59005f
C38 VDD.n0 VSS 1.27211f
C39 VDD.t1 VSS 0.16539f
C40 VDD.n1 VSS 0.17906f
C41 VDD.t0 VSS 0.43352f
C42 VDD.n2 VSS 0.71961f
C43 VH.t1 VSS 0.79137f
C44 VH.t0 VSS 1.73588f
C45 VH.n0 VSS 1.32155f
C46 OUT.t0 VSS 1.95134f
C47 OUT.t1 VSS 1.42949f
C48 OUT.n0 VSS 1.07297f
C49 VL.t0 VSS 1.11649f
.ends
