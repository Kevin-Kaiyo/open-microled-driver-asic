* NGSPICE file created from hs_voltage_robust.ext - technology: gf180mcuD

X0 VSS DI N1 VSS nfet_06v0 ad=1.1p pd=5.88u as=1.1p ps=5.88u w=2.5u l=0.7u
X1 DI DATA VSS ppolyf_u_1k_6p0 r_width=1u r_length=48u
X2 VH CTRL OUT VH pfet_06v0 ad=6.9168p pd=32.32u as=6.9168p ps=32.32u w=15.72u l=0.55u
X3 VDD N1 CTRL VDD pfet_06v0 ad=6.9168p pd=32.32u as=6.9168p ps=32.32u w=15.72u l=0.55u
X4 VL CTRL OUT VSS nfet_06v0 ad=4.4p pd=20.88u as=4.4p ps=20.88u w=10u l=0.7u
X5 VSS N1 CTRL VSS nfet_06v0 ad=4.4p pd=20.88u as=4.4p ps=20.88u w=10u l=0.7u
X6 VDD DI N1 VDD pfet_06v0 ad=1.7292p pd=8.74u as=1.7292p ps=8.74u w=3.93u l=0.55u
C0 VDD VH 0
C1 CTRL OUT 0.79458f
C2 N1 VL 0
C3 DI CTRL 0.00109f
C4 N1 OUT 0.01253f
C5 DI N1 0.16513f
C6 OUT VL 0.59795f
C7 CTRL VH 0.99581f
C8 CTRL VDD 2.2884f
C9 VH VL 0.12573f
C10 N1 VDD 2.00329f
C11 VDD VL 0
C12 VH OUT 2.38453f
C13 VDD OUT 0.01927f
C14 N1 CTRL 1.11343f
C15 DI VDD 0.4645f
C16 CTRL VL 0.37065f
C17 VL VSS 0.95412f
C18 OUT VSS 1.89073f
C19 DATA VSS 0.51379f
C20 VH VSS 9.17589f
C21 VDD VSS 14.618f
C22 CTRL VSS 4.04782f ; **FLOATING
C23 N1 VSS 4.38344f ; **FLOATING
C24 DI VSS 2.14722f ; **FLOATING
