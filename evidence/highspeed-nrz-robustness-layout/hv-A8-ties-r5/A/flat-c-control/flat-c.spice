* NGSPICE file created from hs_voltage_robust.ext - technology: gf180mcuD

X0 VSS DI N1 VSS nfet_06v0 ad=1.1p pd=5.88u as=1.1p ps=5.88u w=2.5u l=0.7u
X1 VH CTRL OUT VH pfet_06v0 ad=6.9168p pd=32.32u as=6.9168p ps=32.32u w=15.72u l=0.55u
X2 VDD N1 CTRL VDD pfet_06v0 ad=6.9168p pd=32.32u as=6.9168p ps=32.32u w=15.72u l=0.55u
X3 VL CTRL OUT VSS nfet_06v0 ad=4.4p pd=20.88u as=4.4p ps=20.88u w=10u l=0.7u
X4 DI DATA VSS ppolyf_u_1k_6p0 r_width=1u r_length=8u
X5 VSS N1 CTRL VSS nfet_06v0 ad=4.4p pd=20.88u as=4.4p ps=20.88u w=10u l=0.7u
X6 VDD DI N1 VDD pfet_06v0 ad=1.7292p pd=8.74u as=1.7292p ps=8.74u w=3.93u l=0.55u
C0 N1 OUT 0.01253f
C1 DI N1 0.16461f
C2 OUT VL 0.59795f
C3 CTRL VH 0.99573f
C4 N1 DATA 0
C5 CTRL VDD 2.28826f
C6 VH VL 0.12564f
C7 N1 VDD 2.00316f
C8 VDD VL 0
C9 VH OUT 2.38448f
C10 VDD OUT 0.01918f
C11 N1 CTRL 1.11312f
C12 DI VDD 0.46365f
C13 CTRL VL 0.37065f
C14 VDD VH 0
C15 CTRL OUT 0.79458f
C16 N1 VL 0
C17 DI CTRL 0.00109f
C18 VL VSS 0.98756f
C19 OUT VSS 1.92414f
C20 DATA VSS 0.49897f
C21 VH VSS 9.17368f
C22 VDD VSS 14.6111f
C23 CTRL VSS 4.12904f ; **FLOATING
C24 N1 VSS 4.45976f ; **FLOATING
C25 DI VSS 2.19969f ; **FLOATING
