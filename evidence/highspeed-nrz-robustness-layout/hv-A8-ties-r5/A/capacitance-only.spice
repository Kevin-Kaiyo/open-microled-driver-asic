* Explicit control derived from full raw RC; original RC retained.
.subckt hs_voltage_robust DATA OUT VDD VH VL VSS
X0 VSS DI N1 VSS nfet_06v0 ad=1.1p pd=5.88u as=1.1p ps=5.88u w=2.5u l=0.7u
X1 VH CTRL OUT VH pfet_06v0 ad=6.9168p pd=32.32u as=6.9168p ps=32.32u w=15.72u l=0.55u
X2 VDD N1 CTRL VDD pfet_06v0 ad=6.9168p pd=32.32u as=6.9168p ps=32.32u w=15.72u l=0.55u
X3 VL CTRL OUT VSS nfet_06v0 ad=4.4p pd=20.88u as=4.4p ps=20.88u w=10u l=0.7u
X5 VSS N1 CTRL VSS nfet_06v0 ad=4.4p pd=20.88u as=4.4p ps=20.88u w=10u l=0.7u
X6 VDD DI N1 VDD pfet_06v0 ad=1.7292p pd=8.74u as=1.7292p ps=8.74u w=3.93u l=0.55u
X4 DI DATA VSS ppolyf_u_1k_6p0 r_width=1u r_length=8u
C0 CTRL VSS 8.77911591706e-18
C1 CTRL VSS 1.29450936044e-15
C2 CTRL VSS 3.00341965109e-16
C3 CTRL VSS 5.6436929895e-17
C4 CTRL VSS 4.09221289677e-16
C5 CTRL VSS 2.17843257105e-16
C6 CTRL VSS 7.83195195986e-16
C7 CTRL VSS 8.15197789493e-17
C8 CTRL VSS 5.14446143688e-16
C9 CTRL VSS 4.62746963234e-16
C10 DATA VSS 2.6658544025e-16
C11 DATA VSS 2.3238855975e-16
C12 DI VSS 5.39270114365e-16
C13 DI VSS 6.78286191316e-16
C14 DI VSS 2.25701027735e-17
C15 DI VSS 1.45130841033e-16
C16 DI VSS 3.97367043913e-16
C17 DI VSS 4.17065706599e-16
C18 N1 VSS 1.14048800515e-17
C19 N1 VSS 1.74900676092e-15
C20 N1 VSS 4.20509193317e-16
C21 N1 VSS 1.83292908514e-17
C22 N1 VSS 2.61308584881e-16
C23 N1 VSS 3.15517613862e-16
C24 N1 VSS 3.80757439709e-16
C25 N1 VSS 2.64756724255e-17
C26 N1 VSS 6.71346102479e-16
C27 N1 VSS 6.05104461501e-16
C28 OUT VSS 6.79424640958e-18
C29 OUT VSS 5.42037267283e-16
C30 OUT VSS 8.10668861613e-16
C31 OUT VSS 5.64639624695e-16
C32 VDD VSS 1.09590903114e-17
C33 VDD VSS 3.89148805125e-15
C34 VDD VSS 5.47758682019e-16
C35 VDD VSS 2.2013527083e-15
C36 VDD VSS 1.32617868824e-15
C37 VDD VSS 5.05948218859e-16
C38 VDD VSS 4.86410762238e-15
C39 VDD VSS 1.26330693864e-15
C40 VH VSS 1.02689956945e-17
C41 VH VSS 3.45781738275e-15
C42 VH VSS 4.54189325407e-15
C43 VH VSS 1.16370036749e-15
C44 VL VSS 2.62373485963e-16
C45 VL VSS 7.25189514037e-16
C46 VDD N1 2.00316e-15
C47 OUT VL 5.97947e-16
C48 N1 CTRL 1.11312e-15
C49 VDD CTRL 2.28826e-15
C50 VDD VH 4.24527e-20
C51 DI N1 1.64612e-16
C52 VH CTRL 9.95729e-16
C53 OUT N1 1.25254e-17
C54 VDD DI 4.63649e-16
C55 OUT VDD 1.91796e-17
C56 DI CTRL 1.094e-18
C57 OUT CTRL 7.94576e-16
C58 VL N1 7.34917e-19
C59 VL VDD 7.40233e-19
C60 OUT VH 2.38448e-15
C61 DATA N1 8.94135e-20
C62 VL CTRL 3.7065e-16
C63 VL VH 1.25638e-16
.ends hs_voltage_robust
