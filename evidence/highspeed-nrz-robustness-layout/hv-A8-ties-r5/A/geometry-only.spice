* Explicit control derived from full raw RC; original RC retained.
.subckt hs_voltage_robust DATA OUT VDD VH VL VSS
X0 VSS DI N1 VSS nfet_06v0 ad=1.1p pd=5.88u as=1.1p ps=5.88u w=2.5u l=0.7u
X1 VH CTRL OUT VH pfet_06v0 ad=6.9168p pd=32.32u as=6.9168p ps=32.32u w=15.72u l=0.55u
X2 VDD N1 CTRL VDD pfet_06v0 ad=6.9168p pd=32.32u as=6.9168p ps=32.32u w=15.72u l=0.55u
X3 VL CTRL OUT VSS nfet_06v0 ad=4.4p pd=20.88u as=4.4p ps=20.88u w=10u l=0.7u
X5 VSS N1 CTRL VSS nfet_06v0 ad=4.4p pd=20.88u as=4.4p ps=20.88u w=10u l=0.7u
X6 VDD DI N1 VDD pfet_06v0 ad=1.7292p pd=8.74u as=1.7292p ps=8.74u w=3.93u l=0.55u
X4 DI DATA VSS ppolyf_u_1k_6p0 r_width=1u r_length=8u
.ends hs_voltage_robust
