* NGSPICE file created from hs_voltage_robust.ext - technology: gf180mcuD

.subckt hs_voltage_robust DATA OUT VDD VH VL VSS
X0 VSS.t2 DI N1.t1 VSS.t1 nfet_06v0 ad=1.1p pd=5.88u as=1.1p ps=5.88u w=2.5u l=0.7u
X1 VH.t1 CTRL.t2 OUT.t0 VH.t0 pfet_06v0 ad=6.9168p pd=32.32u as=6.9168p ps=32.32u w=15.72u l=0.55u
X2 VDD.t3 N1.t2 CTRL.t0 VDD.t2 pfet_06v0 ad=6.9168p pd=32.32u as=6.9168p ps=32.32u w=15.72u l=0.55u
X3 VL.t0 CTRL.t3 OUT.t1 VSS.t5 nfet_06v0 ad=4.4p pd=20.88u as=4.4p ps=20.88u w=10u l=0.7u
X4 DI DATA.t0 VSS.t0 ppolyf_u_1k_6p0 r_width=1u r_length=8u
X5 VSS.t4 N1.t3 CTRL.t1 VSS.t3 nfet_06v0 ad=4.4p pd=20.88u as=4.4p ps=20.88u w=10u l=0.7u
X6 VDD.t1 DI N1.t0 VDD.t0 pfet_06v0 ad=1.7292p pd=8.74u as=1.7292p ps=8.74u w=3.93u l=0.55u
R0 VL VL.t0 12.9175
R1 OUT.n0 OUT.t0 14.8565
R2 OUT.n0 OUT.t1 13.6801
R3 OUT OUT.n0 0.0905
R4 DATA DATA.t0 16.4663
R5 VH.n0 VH.t0 65.8038
R6 VH.n0 VH.t1 13.6041
R7 VH VH.n0 0.0905
R8 VDD.n2 VDD.t0 119.847
R9 VDD.n0 VDD.t2 66.088
R10 VDD.n1 VDD.t1 14.0452
R11 VDD.n0 VDD.t3 13.8883
R12 VDD.n1 VDD.n0 2.01762
R13 VDD.n2 VDD.n1 0.683375
R14 VDD VDD.n2 0.0905
R15 VSS.n9 VSS.n6 2630.16
R16 VSS.n25 VSS.n6 2272.42
R17 VSS.n29 VSS.t5 1764.57
R18 VSS.n25 VSS.n24 1278.23
R19 VSS.n24 VSS.n22 1109.94
R20 VSS.n30 VSS.n29 568.152
R21 VSS.n24 VSS.n13 484.017
R22 VSS.n22 VSS.n14 350.654
R23 VSS.n13 VSS.t1 337.038
R24 VSS.n9 VSS.t1 337.038
R25 VSS.n24 VSS.n23 321.01
R26 VSS.n29 VSS.n2 231.079
R27 VSS.t0 VSS.t3 229.888
R28 VSS.n24 VSS.t0 182.839
R29 VSS.n23 VSS.n2 150.083
R30 VSS.n7 VSS.n4 142.139
R31 VSS.n7 VSS.n5 142.139
R32 VSS.n26 VSS.n5 142.139
R33 VSS.n26 VSS.n4 142.139
R34 VSS.n21 VSS.n15 130.083
R35 VSS.n17 VSS.n16 130.083
R36 VSS.n21 VSS.n17 130.083
R37 VSS.n16 VSS.n14 94.5767
R38 VSS.t5 VSS.n28 69.3003
R39 VSS.n11 VSS.n10 69.2227
R40 VSS.n12 VSS.n11 69.2227
R41 VSS.n12 VSS.n8 69.2227
R42 VSS.n10 VSS.n8 69.2227
R43 VSS.n3 VSS.t2 13.9946
R44 VSS.n30 VSS.n1 13.0578
R45 VSS.n12 VSS.n0 12.9343
R46 VSS.n27 VSS.n26 12.5646
R47 VSS.n28 VSS.t4 12.5432
R48 VSS.n20 VSS.n19 2.64376
R49 VSS.n20 VSS.n18 2.64376
R50 VSS.n19 VSS.n1 2.61441
R51 VSS.n18 VSS.n1 2.61441
R52 VSS.n27 VSS.n3 2.00075
R53 VSS.n6 VSS.n4 1.3005
R54 VSS.n17 VSS.n2 1.3005
R55 VSS.n19 VSS.n17 1.3005
R56 VSS.n8 VSS.t1 1.3005
R57 VSS.n18 VSS.n15 1.3005
R58 VSS.n23 VSS.n5 1.3005
R59 VSS.n11 VSS.t1 1.3005
R60 VSS.n28 VSS.n27 0.70025
R61 VSS.n3 VSS.n0 0.70025
R62 VSS.n13 VSS.n12 0.578278
R63 VSS.n10 VSS.n9 0.578278
R64 VSS.n15 VSS.n14 0.352337
R65 VSS VSS.n30 0.248
R66 VSS.n16 VSS.n1 0.236864
R67 VSS.n21 VSS.n20 0.236864
R68 VSS.n22 VSS.n21 0.236864
R69 VSS.n26 VSS.n25 0.2085
R70 VSS.n25 VSS.n7 0.2085
R71 VSS VSS.n0 0.0905
R72 CTRL.n0 CTRL.t2 142.802
R73 CTRL.n0 CTRL.t3 87.1708
R74 CTRL.n2 CTRL.t1 11.9748
R75 CTRL.n1 CTRL.t0 11.7844
R76 CTRL.n1 CTRL.n0 1.47087
R77 CTRL.n2 CTRL.n1 1.36738
R78 CTRL CTRL.n2 0.068
R79 N1.n0 N1.t2 143.085
R80 N1.n0 N1.t3 87.455
R81 N1.n2 N1.t1 13.7104
R82 N1.n1 N1.t0 12.9083
R83 N1.n1 N1.n0 1.47087
R84 N1.n2 N1.n1 1.36738
R85 N1 N1.n2 0.068
C0 VDD VH 0
C1 CTRL OUT 0.79458f
C2 N1 VL 0
C3 DI CTRL 0.00109f
C4 N1 OUT 0.01253f
C5 DI N1 0.16461f
C6 OUT VL 0.59795f
C7 CTRL VH 0.99573f
C8 N1 DATA 0
C9 CTRL VDD 2.28826f
C10 VH VL 0.12564f
C11 N1 VDD 2.00316f
C12 VDD VL 0
C13 VH OUT 2.38448f
C14 VDD OUT 0.01918f
C15 N1 CTRL 1.11312f
C16 DI VDD 0.46365f
C17 CTRL VL 0.37065f
C18 VL VSS 1.27867f
C19 OUT VSS 1.93759f
C20 DATA VSS 0.49902f
C21 VH VSS 9.1776f
C22 VDD VSS 14.61468f
C23 CTRL VSS 4.14087f
C24 N1 VSS 4.46818f
C25 N1.n0 VSS 1.29192f
C26 N1.t0 VSS 0.28125f
C27 N1.n1 VSS 0.31061f
C28 N1.t1 VSS 1.31609f
C29 N1.n2 VSS 0.24293f
C30 CTRL.n0 VSS 1.74421f
C31 CTRL.t0 VSS 1.30322f
C32 CTRL.n1 VSS 0.40468f
C33 CTRL.t1 VSS 0.95216f
C34 CTRL.n2 VSS 0.3021f
C35 VSS.t2 VSS 1.09984f
C36 VSS.t4 VSS 0.22348f
C37 VDD.t3 VSS 0.66081f
C38 VDD.t2 VSS 1.58963f
C39 VDD.n0 VSS 1.27177f
C40 VDD.t1 VSS 0.16535f
C41 VDD.n1 VSS 0.17901f
C42 VDD.t0 VSS 0.43341f
C43 VDD.n2 VSS 0.71942f
C44 VH.t1 VSS 0.79131f
C45 VH.t0 VSS 1.73577f
C46 VH.n0 VSS 1.32147f
C47 DATA.t0 VSS 0
C48 OUT.t0 VSS 1.95125f
C49 OUT.t1 VSS 1.42942f
C50 OUT.n0 VSS 1.07293f
C51 VL.t0 VSS 1.11636f
.ends
