* C-placement sensitivity control: same full R/MOS, all .ext C at original nets.
.subckt hs_voltage_robust DATA OUT VDD VH VL VSS
X0 VSS.t2 DI.t2 N1.t1 VSS.t1 nfet_06v0 ad=1.1p pd=5.88u as=1.1p ps=5.88u w=2.5u l=0.7u
X1 VH.t1 CTRL.t2 OUT.t0 VH.t0 pfet_06v0 ad=6.9168p pd=32.32u as=6.9168p ps=32.32u w=15.72u l=0.55u
X2 VDD.t3 N1.t2 CTRL.t0 VDD.t2 pfet_06v0 ad=6.9168p pd=32.32u as=6.9168p ps=32.32u w=15.72u l=0.55u
X3 VL.t0 CTRL.t3 OUT.t1 VSS.t5 nfet_06v0 ad=4.4p pd=20.88u as=4.4p ps=20.88u w=10u l=0.7u
X4 DI.t0 DATA.t0 VSS.t0 ppolyf_u_1k_6p0 r_width=1u r_length=8u
X5 VSS.t4 N1.t3 CTRL.t1 VSS.t3 nfet_06v0 ad=4.4p pd=20.88u as=4.4p ps=20.88u w=10u l=0.7u
X6 VDD.t1 DI.t1 N1.t0 VDD.t0 pfet_06v0 ad=1.7292p pd=8.74u as=1.7292p ps=8.74u w=3.93u l=0.55u
R0 VL VL.t0 12.9175
R1 OUT.n0 OUT.t0 14.8565
R2 OUT.n0 OUT.t1 13.6801
R3 OUT OUT.n0 0.0905
R4 DATA DATA.t0 16.4663
R5 VH.n0 VH.t0 65.8038
R6 VH.n0 VH.t1 13.6041
R7 VH VH.n0 0.0905
R8 VDD.n2 VDD.t0 119.847
R9 VDD.n0 VDD.t2 66.088
R10 VDD.n1 VDD.t1 14.0452
R11 VDD.n0 VDD.t3 13.8883
R12 VDD.n1 VDD.n0 2.01762
R13 VDD.n2 VDD.n1 0.683375
R14 VDD VDD.n2 0.0905
R15 VSS.n7 VSS.n6 4902.58
R16 VSS.n19 VSS.t5 2925.48
R17 VSS.n7 VSS.n2 1278.23
R18 VSS.n12 VSS.n2 1109.94
R19 VSS.n4 VSS.n2 484.017
R20 VSS.n20 VSS.n2 361.509
R21 VSS.n13 VSS.n12 350.654
R22 VSS.n6 VSS.t1 337.038
R23 VSS.n4 VSS.t1 337.038
R24 VSS.t0 VSS.t3 229.888
R25 VSS.n2 VSS.t0 182.839
R26 VSS.t5 VSS.n9 157.298
R27 VSS.n18 VSS.n10 130.083
R28 VSS.n18 VSS.n11 130.083
R29 VSS.n14 VSS.n10 130.083
R30 VSS.n20 VSS.n19 109.585
R31 VSS.n13 VSS.n11 94.5767
R32 VSS.n6 VSS.n5 69.8005
R33 VSS.n3 VSS.t2 13.9946
R34 VSS.n21 VSS.n1 13.0578
R35 VSS.n5 VSS.n0 12.9343
R36 VSS.n8 VSS.n7 12.7732
R37 VSS.n9 VSS.t4 12.5432
R38 VSS.n21 VSS.n20 6.65765
R39 VSS.n16 VSS.n15 2.64376
R40 VSS.n17 VSS.n16 2.64376
R41 VSS.n17 VSS.n1 2.61441
R42 VSS.n15 VSS.n1 2.61441
R43 VSS.n8 VSS.n3 2.00075
R44 VSS.n15 VSS.n14 1.3005
R45 VSS.n19 VSS.n18 1.3005
R46 VSS.n18 VSS.n17 1.3005
R47 VSS.n3 VSS.n0 0.70025
R48 VSS.n9 VSS.n8 0.70025
R49 VSS.n5 VSS.n4 0.578278
R50 VSS.n14 VSS.n13 0.352337
R51 VSS VSS.n21 0.248
R52 VSS.n16 VSS.n10 0.236864
R53 VSS.n12 VSS.n10 0.236864
R54 VSS.n11 VSS.n1 0.236864
R55 VSS VSS.n0 0.0905
R56 CTRL.n0 CTRL.t2 142.802
R57 CTRL.n0 CTRL.t3 87.1708
R58 CTRL.n4 CTRL.n3 11.811
R59 CTRL.n1 CTRL.t0 11.7844
R60 CTRL.n1 CTRL.n0 1.47087
R61 CTRL.n4 CTRL.n1 1.36738
R62 CTRL.n3 CTRL.t1 0.1643
R63 CTRL.n3 CTRL.n2 0.1139
R64 CTRL CTRL.n4 0.068
R65 N1.n0 N1.t2 143.085
R66 N1.n0 N1.t3 87.455
R67 N1.n4 N1.n3 13.0552
R68 N1.n1 N1.t0 12.9083
R69 N1.n1 N1.n0 1.47087
R70 N1.n4 N1.n1 1.36738
R71 N1.n3 N1.t1 0.6557
R72 N1.n3 N1.n2 0.4541
R73 N1 N1.n4 0.068
R74 DI.n0 DI.t1 51.0678
R75 DI.n0 DI.t2 44.4281
R76 DI DI.t0 14.958
R77 DI.t0 DI.n1 5.98411
R78 DI DI.n0 0.068
C0 CTRL VSS 4.0478200000000004e-15
C1 DATA VSS 4.9897400000000007e-16
C2 DI VSS 2.1472199999999998e-15
C3 N1 VSS 4.3834600000000004e-15
C4 OUT VSS 1.8907300000000003e-15
C5 VDD VSS 1.4618000000000002e-14
C6 VH VSS 9.1758900000000001e-15
C7 VL VSS 9.541250000000001e-16
C8 DATA N1 8.9413500000000012e-20
C9 VDD N1 2.0032900000000003e-15
C10 OUT N1 1.25254e-17
C11 OUT VDD 1.9269200000000002e-17
C12 N1 CTRL 1.1134300000000002e-15
C13 VDD CTRL 2.2884000000000003e-15
C14 VDD VH 4.6165300000000005e-20
C15 OUT CTRL 7.9457600000000011e-16
C16 VL N1 7.3491700000000011e-19
C17 VL VDD 7.9390800000000001e-19
C18 OUT VH 2.3845300000000005e-15
C19 OUT VL 5.9794700000000003e-16
C20 DI N1 1.6512899999999999e-16
C21 VH CTRL 9.9580800000000007e-16
C22 VDD DI 4.64497e-16
C23 VL CTRL 3.7065000000000002e-16
C24 VL VH 1.2572800000000001e-16
C25 DI CTRL 1.0940000000000001e-18
.ends hs_voltage_robust
