* NGSPICE file created from hs_voltage_robust.ext - technology: gf180mcuD

.subckt hs_voltage_robust DATA OUT VDD VH VL VSS
X0 VSS.t2 DI.t2 N1.t1 VSS.t1 nfet_06v0 ad=1.1p pd=5.88u as=1.1p ps=5.88u w=2.5u l=0.7u
X1 VH.t1 CTRL.t2 OUT.t0 VH.t0 pfet_06v0 ad=6.9168p pd=32.32u as=6.9168p ps=32.32u w=15.72u l=0.55u
X2 VDD.t3 N1.t2 CTRL.t0 VDD.t2 pfet_06v0 ad=6.9168p pd=32.32u as=6.9168p ps=32.32u w=15.72u l=0.55u
X3 VL.t0 CTRL.t3 OUT.t1 VSS.t5 nfet_06v0 ad=4.4p pd=20.88u as=4.4p ps=20.88u w=10u l=0.7u
X4 DI.t0 DATA.t0 VSS.t0 ppolyf_u_1k_6p0 r_width=1u r_length=8u
X5 VSS.t4 N1.t3 CTRL.t1 VSS.t3 nfet_06v0 ad=4.4p pd=20.88u as=4.4p ps=20.88u w=10u l=0.7u
X6 VDD.t1 DI.t1 N1.t0 VDD.t0 pfet_06v0 ad=1.7292p pd=8.74u as=1.7292p ps=8.74u w=3.93u l=0.55u
R0 VL VL.t0 12.9175
R1 OUT.n0 OUT.t0 14.8565
R2 OUT.n0 OUT.t1 13.6801
R3 OUT OUT.n0 0.0905
R4 DATA DATA.t0 16.4663
R5 VH.n0 VH.t0 65.8038
R6 VH.n0 VH.t1 13.6041
R7 VH VH.n0 0.0905
R8 VDD.n2 VDD.t0 119.847
R9 VDD.n0 VDD.t2 66.088
R10 VDD.n1 VDD.t1 14.0452
R11 VDD.n0 VDD.t3 13.8883
R12 VDD.n1 VDD.n0 2.01762
R13 VDD.n2 VDD.n1 0.683375
R14 VDD VDD.n2 0.0905
R15 VSS.n7 VSS.n6 4902.58
R16 VSS.n19 VSS.t5 2925.48
R17 VSS.n7 VSS.n2 1278.23
R18 VSS.n12 VSS.n2 1109.94
R19 VSS.n4 VSS.n2 484.017
R20 VSS.n20 VSS.n2 361.509
R21 VSS.n13 VSS.n12 350.654
R22 VSS.n6 VSS.t1 337.038
R23 VSS.n4 VSS.t1 337.038
R24 VSS.t0 VSS.t3 229.888
R25 VSS.n2 VSS.t0 182.839
R26 VSS.t5 VSS.n9 157.298
R27 VSS.n18 VSS.n10 130.083
R28 VSS.n18 VSS.n11 130.083
R29 VSS.n14 VSS.n10 130.083
R30 VSS.n20 VSS.n19 109.585
R31 VSS.n13 VSS.n11 94.5767
R32 VSS.n6 VSS.n5 69.8005
R33 VSS.n3 VSS.t2 13.9946
R34 VSS.n21 VSS.n1 13.0578
R35 VSS.n5 VSS.n0 12.9343
R36 VSS.n8 VSS.n7 12.7732
R37 VSS.n9 VSS.t4 12.5432
R38 VSS.n21 VSS.n20 6.65765
R39 VSS.n16 VSS.n15 2.64376
R40 VSS.n17 VSS.n16 2.64376
R41 VSS.n17 VSS.n1 2.61441
R42 VSS.n15 VSS.n1 2.61441
R43 VSS.n8 VSS.n3 2.00075
R44 VSS.n15 VSS.n14 1.3005
R45 VSS.n19 VSS.n18 1.3005
R46 VSS.n18 VSS.n17 1.3005
R47 VSS.n3 VSS.n0 0.70025
R48 VSS.n9 VSS.n8 0.70025
R49 VSS.n5 VSS.n4 0.578278
R50 VSS.n14 VSS.n13 0.352337
R51 VSS VSS.n21 0.248
R52 VSS.n16 VSS.n10 0.236864
R53 VSS.n12 VSS.n10 0.236864
R54 VSS.n11 VSS.n1 0.236864
R55 VSS VSS.n0 0.0905
R56 CTRL.n0 CTRL.t2 142.802
R57 CTRL.n0 CTRL.t3 87.1708
R58 CTRL.n4 CTRL.n3 11.811
R59 CTRL.n1 CTRL.t0 11.7844
R60 CTRL.n1 CTRL.n0 1.47087
R61 CTRL.n4 CTRL.n1 1.36738
R62 CTRL.n3 CTRL.t1 0.1643
R63 CTRL.n3 CTRL.n2 0.1139
R64 CTRL CTRL.n4 0.068
R65 N1.n0 N1.t2 143.085
R66 N1.n0 N1.t3 87.455
R67 N1.n4 N1.n3 13.0552
R68 N1.n1 N1.t0 12.9083
R69 N1.n1 N1.n0 1.47087
R70 N1.n4 N1.n1 1.36738
R71 N1.n3 N1.t1 0.6557
R72 N1.n3 N1.n2 0.4541
R73 N1 N1.n4 0.068
R74 DI.n0 DI.t1 51.0678
R75 DI.n0 DI.t2 44.4281
R76 DI DI.t0 14.958
R77 DI.t0 DI.n1 5.98411
R78 DI DI.n0 0.068
C0 N1 OUT 0.01253f
C1 DI N1 0.16513f
C2 OUT VL 0.59795f
C3 N1 DATA 0
C4 CTRL VH 0.99581f
C5 CTRL VDD 2.2884f
C6 VH VL 0.12573f
C7 N1 VDD 2.00329f
C8 VDD VL 0
C9 VH OUT 2.38453f
C10 VDD OUT 0.01927f
C11 N1 CTRL 1.11343f
C12 DI VDD 0.4645f
C13 CTRL VL 0.37065f
C14 VDD VH 0
C15 CTRL OUT 0.79458f
C16 N1 VL 0
C17 DI CTRL 0.00109f
C18 VL VSS 1.24527f
 ; **nodeattr VL : res:drive
C19 OUT VSS 1.90418f
 ; **nodeattr OUT : res:drive
C20 DATA VSS 0.49902f
 ; **nodeattr DATA : res:drive
C21 VH VSS 9.17981f
 ; **nodeattr VH : res:drive
C22 VDD VSS 14.62158f
 ; **nodeattr VDD : res:drive
C23 CTRL VSS 4.05965f
 ; **nodeattr CTRL : res:drive
C24 N1 VSS 4.39189f
 ; **nodeattr N1 : res:drive
C25 DI VSS 2.30185f
 ; **nodeattr DI : res:drive
C26 DI.n0 VSS 0.19449f
C27 DI.n1 VSS 0.00647f
C28 DI.t0 VSS 0.04161f
C29 N1.n0 VSS 1.29229f
C30 N1.t0 VSS 0.3383f
C31 N1.n1 VSS 0.3107f
C32 N1.t1 VSS 0.07935f
C33 N1.n2 VSS 0.01354f
C34 N1.n3 VSS 0.19307f
C35 N1.n4 VSS 0.23313f
C36 CTRL.n0 VSS 1.74437f
C37 CTRL.t0 VSS 1.30339f
C38 CTRL.n1 VSS 0.40472f
C39 CTRL.t1 VSS 0.3334f
C40 CTRL.n2 VSS 0.07605f
C41 CTRL.n3 VSS 0.55143f
C42 CTRL.n4 VSS 0.29355f
C43 VSS.t2 VSS 0.05979f
C44 VSS.t4 VSS 0.22355f
C45 VDD.t3 VSS 0.66099f
C46 VDD.t2 VSS 1.59005f
C47 VDD.n0 VSS 1.27211f
C48 VDD.t1 VSS 0.22236f
C49 VDD.n1 VSS 0.17906f
C50 VDD.t0 VSS 0.43352f
C51 VDD.n2 VSS 0.71961f
C52 VH.t1 VSS 0.79137f
C53 VH.t0 VSS 1.73588f
C54 VH.n0 VSS 1.32155f
C55 DATA.t0 VSS 0
C56 OUT.t0 VSS 1.95134f
C57 OUT.t1 VSS 1.42949f
C58 OUT.n0 VSS 1.07297f
C59 VL.t0 VSS 1.11649f
.ends
