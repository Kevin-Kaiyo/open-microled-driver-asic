* Audited RC model assembly from build/highspeed-nrz-pvt-layout/poly58-r1/A/readback/hs_voltage_pvt.ext.
* Original Magic RC preserved in ../unmodified-full-rc/.
* R/MOS unchanged; C counted once with post-simplification allocation weights.
* Coupling remains at original logical nodes; no EM claim.
.subckt hs_voltage_pvt DATA OUT VDD VH VL VSS
X0 VL.t0 CTRL.t3 OUT.t1 VSS.t5 nfet_03v3 ad=1.76p pd=8.88u as=1.76p ps=8.88u w=4u l=0.28u
X1 VSS.t4 N1.t3 CTRL.t1 VSS.t3 nfet_03v3 ad=1.76p pd=8.88u as=1.76p ps=8.88u w=4u l=0.28u
X2 DATA.t0 DI.t0 VSS.t0 ppolyf_u_1k_6p0 r_width=1u r_length=58u
X3 VSS.t2 DI.t2 N1.t0 VSS.t1 nfet_03v3 ad=0.44p pd=2.88u as=0.44p ps=2.88u w=1u l=0.28u
X4 VH.t1 CTRL.t2 OUT.t0 VH.t0 pfet_03v3 ad=3.52p pd=16.88u as=3.52p ps=16.88u w=8u l=0.28u
X5 VDD.t1 DI.t1 N1.t1 VDD.t0 pfet_03v3 ad=0.88p pd=4.88u as=0.88p ps=4.88u w=2u l=0.28u
X6 VDD.t3 N1.t2 CTRL.t0 VDD.t2 pfet_03v3 ad=3.52p pd=16.88u as=3.52p ps=16.88u w=8u l=0.28u
R0 VL VL.t0 13.6507
R1 OUT.n0 OUT.t0 15.0997
R2 OUT.n0 OUT.t1 14.4133
R3 OUT OUT.n0 0.0905
R4 DATA DATA.t0 37.1332
R5 VH.n0 VH.t0 82.3849
R6 VH.n0 VH.t1 13.8338
R7 VH VH.n0 0.0905
R8 VDD.n2 VDD.t0 146.069
R9 VDD.n0 VDD.t2 82.6691
R10 VDD.n1 VDD.t1 15.1421
R11 VDD.n0 VDD.t3 14.118
R12 VDD.n1 VDD.n0 2.048
R13 VDD.n2 VDD.n1 0.653
R14 VDD VDD.n2 0.0905
R15 VSS VSS.n5 1789.65
R16 VSS.t3 VSS.t0 1619.68
R17 VSS.t3 VSS.n1 1464.44
R18 VSS.n5 VSS.t3 1307.61
R19 VSS.n5 VSS.t5 618.931
R20 VSS.t3 VSS.n4 421.259
R21 VSS.n1 VSS.t1 401.365
R22 VSS.n2 VSS.t5 200.181
R23 VSS.n3 VSS.t2 16.8674
R24 VSS.n1 VSS.n0 13.9889
R25 VSS.n2 VSS.t4 13.2764
R26 VSS.n4 VSS.n3 2.048
R27 VSS.n3 VSS.n0 0.653
R28 VSS.n4 VSS.n2 0.653
R29 VSS VSS.n0 0.0905
R30 CTRL.n0 CTRL.t2 147.206
R31 CTRL.n0 CTRL.t3 93.2388
R32 CTRL.n4 CTRL.n3 12.2985
R33 CTRL.n1 CTRL.t0 12.0444
R34 CTRL.n1 CTRL.n0 1.4405
R35 CTRL.n4 CTRL.n1 1.3505
R36 CTRL.n3 CTRL.t1 0.41
R37 CTRL.n3 CTRL.n2 0.284
R38 CTRL CTRL.n4 0.068
R39 N1.n0 N1.t2 147.489
R40 N1.n0 N1.t3 93.5231
R41 N1.n4 N1.n3 14.9452
R42 N1.n1 N1.t1 14.0052
R43 N1.n3 N1.t0 1.6385
R44 N1.n1 N1.n0 1.4405
R45 N1.n4 N1.n1 1.3505
R46 N1.n3 N1.n2 1.1345
R47 N1 N1.n4 0.068
R48 DI.n0 DI.t1 70.27
R49 DI.n0 DI.t2 55.7659
R50 DI DI.n2 15.1948
R51 DI.n2 DI.t0 3.1395
R52 DI.n2 DI.n1 1.3145
R53 DI DI.n0 0.068
C0 CTRL VSS 1.2746160235927899e-17
C1 CTRL.n0 VSS 1.4414324105021711e-15
C2 CTRL.n1 VSS 4.3603234009631566e-16
C3 CTRL.n2 VSS 3.2775898596481725e-17
C4 CTRL.n3 VSS 3.4075479233275463e-16
C5 CTRL.n4 VSS 3.2248394289902482e-16
C6 CTRL.t0 VSS 6.6239744806334119e-16
C7 CTRL.t1 VSS 4.7342953363566108e-17
C8 CTRL.t2 VSS 2.3951719687288749e-16
C9 CTRL.t3 VSS 1.6513685703752924e-16
C10 DATA VSS 2.4338623636320809e-15
C11 DATA.t0 VSS 1.0919276363679187e-15
C12 DI VSS 5.2081380865060025e-16
C13 DI.n0 VSS 2.3311706391276491e-15
C14 DI.n1 VSS 1.2137473174095905e-17
C15 DI.n2 VSS 1.3350439448773498e-16
C16 DI.t0 VSS 2.8995105524262816e-17
C17 DI.t1 VSS 2.7873168743217363e-16
C18 DI.t2 VSS 2.5060689160348336e-16
C19 N1 VSS 1.4770684650686069e-17
C20 N1.n0 VSS 1.7592269197169884e-15
C21 N1.n1 VSS 5.5712317512244106e-16
C22 N1.n2 VSS 9.4954622072556785e-18
C23 N1.n3 VSS 2.3942309416190815e-16
C24 N1.n4 VSS 4.3483952742184555e-16
C25 N1.t0 VSS 1.3715673876044157e-17
C26 N1.t1 VSS 3.3975468485369031e-16
C27 N1.t2 VSS 2.808239404000696e-16
C28 N1.t3 VSS 1.9547683758907152e-16
C29 OUT VSS 7.8827453580364072e-18
C30 OUT.n0 VSS 6.426748931307756e-16
C31 OUT.t0 VSS 5.9609129288060503e-16
C32 OUT.t1 VSS 3.7993106863058307e-16
C33 VDD VSS 1.1324532020324012e-17
C34 VDD.n0 VSS 3.0363753966508361e-15
C35 VDD.n1 VSS 5.8596205971906048e-16
C36 VDD.n2 VSS 1.7478319884853365e-15
C37 VDD.t0 VSS 7.2480704715220856e-16
C38 VDD.t1 VSS 3.8084970038583223e-16
C39 VDD.t2 VSS 2.2253520697525815e-15
C40 VDD.t3 VSS 8.106872058338228e-16
C41 VH VSS 1.0333261268184929e-17
C42 VH.n0 VSS 2.5717967907885023e-15
C43 VH.t0 VSS 2.020862682117506e-15
C44 VH.t1 VSS 7.1983726582580738e-16
C45 VL VSS 2.6313057412991092e-16
C46 VL.t0 VSS 3.8602042587008906e-16
C47 VL CTRL 1.9477200000000002e-16
C48 N1 CTRL 7.0472500000000003e-16
C49 VL VH 1.1639200000000001e-16
C50 DATA DI 8.4845800000000004e-21
C51 VDD CTRL 1.6369700000000001e-15
C52 DATA N1 1.4866800000000001e-20
C53 VH CTRL 6.7901300000000011e-16
C54 OUT VL 7.1160699999999999e-16
C55 OUT N1 8.8674700000000008e-18
C56 DI N1 4.0814400000000003e-16
C57 OUT VDD 1.7550800000000001e-17
C58 VDD DI 6.1210700000000005e-16
C59 OUT CTRL 4.2240800000000006e-16
C60 VL N1 7.8807500000000004e-19
C61 DI CTRL 8.6813300000000009e-18
C62 VL VDD 5.89101e-19
C63 OUT VH 1.8236100000000001e-15
C64 VDD N1 1.6143500000000001e-15
.ends hs_voltage_pvt
