* Audited RC model assembly from build/highspeed-nrz-pvt-layout/poly58-r1/B/readback/hs_steering_pvt.ext.
* Original Magic RC preserved in ../unmodified-full-rc/.
* R/MOS unchanged; C counted once with post-simplification allocation weights.
* Coupling remains at original logical nodes; no EM claim.
.subckt hs_steering_pvt DATA OUT VDD VSS BIAS DUMMY
X0 VDD.t3 GB.t3 GP.t1 VDD.t2 pfet_03v3 ad=0.88p pd=4.88u as=0.88p ps=4.88u w=2u l=0.28u
X1 VX.t2 GP.t2 OUT.t1 VSS.t12 nfet_03v3 ad=0.44p pd=2.88u as=0.44p ps=2.88u w=1u l=0.28u
X2 VSS.t10 GB.t4 GP.t0 VSS.t9 nfet_03v3 ad=0.44p pd=2.88u as=0.44p ps=2.88u w=1u l=0.28u
X3 DATA.t0 DI.t0 VSS.t6 ppolyf_u_1k_6p0 r_width=1u r_length=58u
X4 VSS.t8 DI.t2 GB.t0 VSS.t7 nfet_03v3 ad=0.44p pd=2.88u as=0.44p ps=2.88u w=1u l=0.28u
X5 VX.t1 GB.t2 DUMMY.t0 VSS.t11 nfet_03v3 ad=0.44p pd=2.88u as=0.44p ps=2.88u w=1u l=0.28u
X6 VSS.t5 BIAS.t2 OUT.t0 VSS.t4 nfet_03v3 ad=0.88p pd=4.88u as=0.88p ps=4.88u w=2u l=1u
X7 VDD.t1 DI.t1 GB.t1 VDD.t0 pfet_03v3 ad=0.88p pd=4.88u as=0.88p ps=4.88u w=2u l=0.28u
X8 VSS.t1 BIAS.t3 VX.t0 VSS.t0 nfet_03v3 ad=2.5344p pd=12.4u as=2.5344p ps=12.4u w=5.76u l=1u
X9 VSS.t3 BIAS.t0 BIAS.t1 VSS.t2 nfet_03v3 ad=0.88p pd=4.88u as=0.88p ps=4.88u w=2u l=1u
R0 BIAS.n2 BIAS.t3 50.8382
R1 BIAS.n0 BIAS.t0 36.8399
R2 BIAS.n1 BIAS.t2 36.6689
R3 BIAS.n0 BIAS.t1 14.7577
R4 BIAS.n2 BIAS.n1 1.3505
R5 BIAS.n1 BIAS.n0 1.1795
R6 BIAS BIAS.n2 0.0905
R7 DUMMY DUMMY.t0 16.9574
R8 OUT.n0 OUT.t0 19.5793
R9 OUT.n0 OUT.t1 18.0043
R10 OUT OUT.n0 0.0905
R11 DATA DATA.t0 36.849
R12 VDD.n2 VDD.t0 146.069
R13 VDD.n0 VDD.t2 146.069
R14 VDD.n0 VDD.t3 15.7946
R15 VDD.n1 VDD.t1 15.1421
R16 VDD.n1 VDD.n0 2.048
R17 VDD.n2 VDD.n1 0.653
R18 VDD VDD.n2 0.0905
R19 VSS.t9 VSS.n25 1834.27
R20 VSS.t9 VSS.t6 1470.93
R21 VSS.t9 VSS.n1 1464.44
R22 VSS.t9 VSS.n2 1447.52
R23 VSS.n19 VSS.n18 572.913
R24 VSS.n24 VSS.n5 518.92
R25 VSS.n10 VSS.n9 465.252
R26 VSS.n11 VSS.n6 464.928
R27 VSS.t9 VSS.n4 415.923
R28 VSS.n1 VSS.t7 401.365
R29 VSS VSS.t9 393.151
R30 VSS.t4 VSS.n10 217.468
R31 VSS.n6 VSS.t0 217.468
R32 VSS.n11 VSS.t4 217.468
R33 VSS.n25 VSS.t0 214.468
R34 VSS.t11 VSS.n5 163.476
R35 VSS.t12 VSS.n2 163.476
R36 VSS.n18 VSS.t12 163.476
R37 VSS.n19 VSS.t11 163.476
R38 VSS.n9 VSS.t2 122.451
R39 VSS.n23 VSS.n6 99.9027
R40 VSS.n12 VSS.n10 63.7434
R41 VSS.n20 VSS.n5 47.3183
R42 VSS.n18 VSS.n17 47.3183
R43 VSS.n15 VSS.t10 17.4359
R44 VSS.n3 VSS.t8 17.4359
R45 VSS.n8 VSS.t3 15.7754
R46 VSS.n7 VSS.t5 15.0419
R47 VSS.n1 VSS.n0 14.5573
R48 VSS.n9 VSS.n8 14.0582
R49 VSS.n21 VSS.n20 14.0218
R50 VSS.n17 VSS.n16 14.0218
R51 VSS.n13 VSS.n12 13.6394
R52 VSS.n14 VSS.t1 13.4572
R53 VSS.n23 VSS.n22 13.2432
R54 VSS.n25 VSS.n24 3.00004
R55 VSS.n16 VSS.n15 2.048
R56 VSS.n4 VSS.n3 2.048
R57 VSS.n22 VSS.n21 1.3505
R58 VSS.n21 VSS.n16 1.3505
R59 VSS.n17 VSS.n2 1.0405
R60 VSS.n20 VSS.n19 1.0405
R61 VSS.n12 VSS.n11 0.743357
R62 VSS.n13 VSS.n7 0.734
R63 VSS.n22 VSS.n14 0.734
R64 VSS.n15 VSS.n4 0.653
R65 VSS.n3 VSS.n0 0.653
R66 VSS.n8 VSS.n7 0.617
R67 VSS.n14 VSS.n13 0.617
R68 VSS.n24 VSS.n23 0.347167
R69 VSS VSS.n0 0.0905
R70 VX.n0 VX.t1 16.0148
R71 VX.n1 VX.t2 16.0148
R72 VX.n0 VX.t0 13.1252
R73 VX.n1 VX.n0 1.3505
R74 VX VX.n1 0.068
R75 GP.n0 GP.t2 55.2164
R76 GP.n3 GP.n2 14.661
R77 GP.n0 GP.t1 13.721
R78 GP.n2 GP.t0 1.6385
R79 GP.n3 GP.n0 1.3505
R80 GP.n2 GP.n1 1.1345
R81 GP GP.n3 0.068
R82 GB.n0 GB.t3 67.2148
R83 GB.n0 GB.t2 56.7606
R84 GB.n1 GB.t4 54.0607
R85 GB.n5 GB.n4 14.9452
R86 GB.n2 GB.t1 14.0052
R87 GB.n4 GB.t0 1.6385
R88 GB.n2 GB.n1 1.4405
R89 GB.n5 GB.n2 1.3505
R90 GB.n1 GB.n0 1.3505
R91 GB.n4 GB.n3 1.1345
R92 GB GB.n5 0.068
R93 DI.n0 DI.t1 70.27
R94 DI.n0 DI.t2 55.7659
R95 DI DI.n2 15.1948
R96 DI.n2 DI.t0 3.1395
R97 DI.n2 DI.n1 1.3145
R98 DI DI.n0 0.068
C0 BIAS VSS 1.5302623938722793e-17
C1 BIAS.n0 VSS 1.3359040441767979e-15
C2 BIAS.n1 VSS 1.0026332863074548e-15
C3 BIAS.n2 VSS 1.0825718431386194e-15
C4 BIAS.t0 VSS 6.0409784069498595e-16
C5 BIAS.t1 VSS 4.5852416010965989e-16
C6 BIAS.t2 VSS 6.0056664298032018e-16
C7 BIAS.t3 VSS 9.677695586534401e-16
C8 DATA VSS 2.387520906608874e-15
C9 DATA.t0 VSS 1.0659590933911265e-15
C10 DI VSS 5.2310856751001991e-16
C11 DI.n0 VSS 2.341435323871279e-15
C12 DI.n1 VSS 1.2190928457433221e-17
C13 DI.n2 VSS 1.3409253553401211e-16
C14 DI.t0 VSS 2.9122798627063523e-17
C15 DI.t1 VSS 2.7995943447767441e-16
C16 DI.t2 VSS 2.5171041152251809e-16
C17 DUMMY VSS 3.9512940335194812e-16
C18 DUMMY.t0 VSS 2.5804459664805188e-16
C19 GB VSS 1.5166805707704492e-17
C20 GB.n0 VSS 1.7248048027868496e-15
C21 GB.n1 VSS 7.9463712912095312e-16
C22 GB.n2 VSS 5.7206532989209595e-16
C23 GB.n3 VSS 9.7501332419613007e-18
C24 GB.n4 VSS 2.4584448138882448e-16
C25 GB.n5 VSS 4.4650281129118627e-16
C26 GB.t0 VSS 1.408348237852163e-17
C27 GB.t1 VSS 3.4886695308394836e-16
C28 GB.t2 VSS 1.9543778040542363e-16
C29 GB.t3 VSS 1.6832050753065701e-16
C30 GB.t4 VSS 1.5701978317187458e-16
C31 GP VSS 1.5230736106536514e-17
C32 GP.n0 VSS 1.1762644922659855e-15
C33 GP.n1 VSS 9.7911908012146945e-18
C34 GP.n2 VSS 2.2624990073187265e-16
C35 GP.n3 VSS 4.1940323219122345e-16
C36 GP.t0 VSS 1.414285942619613e-17
C37 GP.t1 VSS 3.2843074461922799e-16
C38 GP.t2 VSS 1.6776684385774338e-16
C39 OUT VSS 1.6668150030845878e-17
C40 OUT.n0 VSS 1.9892501713111469e-15
C41 OUT.t0 VSS 8.0446320093398526e-16
C42 OUT.t1 VSS 4.3818847772402255e-16
C43 VDD VSS 1.2108687477407642e-17
C44 VDD.n0 VSS 2.4883639354575836e-15
C45 VDD.n1 VSS 6.2653705613101715e-16
C46 VDD.n2 VSS 1.8688539240775266e-15
C47 VDD.t0 VSS 7.7499564688835696e-16
C48 VDD.t1 VSS 4.0722143320854326e-16
C49 VDD.t2 VSS 7.7499564688835696e-16
C50 VDD.t3 VSS 4.2635366987120874e-16
C51 VX VSS 1.6250393282048887e-17
C52 VX.n0 VSS 8.9507395330380848e-16
C53 VX.n1 VSS 4.3991142988750362e-16
C54 VX.t0 VSS 6.7121968174099171e-16
C55 VX.t1 VSS 2.2157227089282363e-16
C56 VX.t2 VSS 2.2157227089282363e-16
C57 DI GP 7.2814600000000004e-18
C58 VDD DI 6.0485400000000013e-16
C59 OUT VX 3.9868200000000004e-16
C60 GB BIAS 8.6539100000000011e-17
C61 GP DUMMY 7.0441500000000011e-18
C62 GB GP 8.3362400000000009e-16
C63 VDD GB 1.5511600000000001e-15
C64 OUT DUMMY 2.6675400000000002e-19
C65 GB OUT 6.4230199999999999e-17
C66 DATA GB 1.4866800000000001e-20
C67 VDD GP 9.1993800000000008e-16
C68 OUT BIAS 2.1191100000000002e-16
C69 VX DUMMY 4.4542400000000002e-16
C70 GP OUT 1.3469500000000001e-16
C71 VDD OUT 5.9964899999999999e-18
C72 GB VX 2.4578600000000003e-16
C73 VX BIAS 2.54311e-16
C74 DI GB 4.1597000000000008e-16
C75 GB DUMMY 1.6528000000000002e-16
C76 GP VX 1.3578899999999999e-16
C77 VDD VX 2.3310800000000003e-19
C78 DUMMY BIAS 8.4883400000000002e-19
.ends hs_steering_pvt
