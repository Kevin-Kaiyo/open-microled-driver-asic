* NGSPICE file created from hs_steering_pvt.ext - technology: gf180mcuD

X0 VDD GB GP VDD pfet_03v3 ad=0.88p pd=4.88u as=0.88p ps=4.88u w=2u l=0.28u
X1 DI DATA VSS ppolyf_u_1k_6p0 r_width=1u r_length=58u
X2 VX GP OUT VSS nfet_03v3 ad=0.44p pd=2.88u as=0.44p ps=2.88u w=1u l=0.28u
X3 VSS GB GP VSS nfet_03v3 ad=0.44p pd=2.88u as=0.44p ps=2.88u w=1u l=0.28u
X4 VSS DI GB VSS nfet_03v3 ad=0.44p pd=2.88u as=0.44p ps=2.88u w=1u l=0.28u
X5 VX GB DUMMY VSS nfet_03v3 ad=0.44p pd=2.88u as=0.44p ps=2.88u w=1u l=0.28u
X6 VSS BIAS OUT VSS nfet_03v3 ad=0.88p pd=4.88u as=0.88p ps=4.88u w=2u l=1u
X7 VDD DI GB VDD pfet_03v3 ad=0.88p pd=4.88u as=0.88p ps=4.88u w=2u l=0.28u
X8 VSS BIAS VX VSS nfet_03v3 ad=2.5344p pd=12.4u as=2.5344p ps=12.4u w=5.76u l=1u
X9 VSS BIAS BIAS VSS nfet_03v3 ad=0.88p pd=4.88u as=0.88p ps=4.88u w=2u l=1u
C0 VX DUMMY 0.44542f
C1 GB GP 0.83362f
C2 VX OUT 0.39868f
C3 GB BIAS 0.08654f
C4 GP DUMMY 0.00704f
C5 DUMMY BIAS 0
C6 GB DUMMY 0.16528f
C7 GP OUT 0.1347f
C8 DI GP 0
C9 OUT BIAS 0.21191f
C10 VX VDD 0
C11 GB OUT 0.06423f
C12 DI GB 0.06585f
C13 OUT DUMMY 0
C14 GP VDD 0.91994f
C15 GB VDD 1.55591f
C16 GP VX 0.13579f
C17 VX BIAS 0.25431f
C18 VDD OUT 0.006f
C19 DI VDD 0.35077f
C20 GB VX 0.24579f
C21 BIAS VSS 6.06737f
C22 DUMMY VSS 0.65317f
C23 OUT VSS 3.24857f
C24 DATA VSS 0.51379f
C25 VDD VSS 7.45349f
C26 VX VSS 2.4656f ; **FLOATING
C27 GP VSS 2.35728f ; **FLOATING
C28 GB VSS 4.88662f ; **FLOATING
C29 DI VSS 2.12594f ; **FLOATING
