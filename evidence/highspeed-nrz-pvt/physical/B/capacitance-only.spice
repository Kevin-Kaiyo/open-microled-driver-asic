* Explicit control derived from full raw RC; original RC retained.
.subckt hs_steering_pvt DATA OUT VDD VSS BIAS DUMMY
X0 VDD GB GP VDD pfet_03v3 ad=0.88p pd=4.88u as=0.88p ps=4.88u w=2u l=0.28u
X2 VX GP OUT VSS nfet_03v3 ad=0.44p pd=2.88u as=0.44p ps=2.88u w=1u l=0.28u
X3 VSS GB GP VSS nfet_03v3 ad=0.44p pd=2.88u as=0.44p ps=2.88u w=1u l=0.28u
X4 VSS DI GB VSS nfet_03v3 ad=0.44p pd=2.88u as=0.44p ps=2.88u w=1u l=0.28u
X5 VX GB DUMMY VSS nfet_03v3 ad=0.44p pd=2.88u as=0.44p ps=2.88u w=1u l=0.28u
X6 VSS BIAS OUT VSS nfet_03v3 ad=0.88p pd=4.88u as=0.88p ps=4.88u w=2u l=1u
X7 VDD DI GB VDD pfet_03v3 ad=0.88p pd=4.88u as=0.88p ps=4.88u w=2u l=0.28u
X8 VSS BIAS VX VSS nfet_03v3 ad=2.5344p pd=12.4u as=2.5344p ps=12.4u w=5.76u l=1u
X9 VSS BIAS BIAS VSS nfet_03v3 ad=0.88p pd=4.88u as=0.88p ps=4.88u w=2u l=1u
X1 DI DATA VSS ppolyf_u_1k_6p0 r_width=1u r_length=58u
C0 BIAS VSS 1.53026239387e-17
C1 BIAS VSS 1.33590404418e-15
C2 BIAS VSS 1.00263328631e-15
C3 BIAS VSS 1.08257184314e-15
C4 BIAS VSS 6.04097840695e-16
C5 BIAS VSS 4.5852416011e-16
C6 BIAS VSS 6.0056664298e-16
C7 BIAS VSS 9.67769558653e-16
C8 DATA VSS 5.13794e-16
C9 DI VSS 6.70811732717e-16
C10 DI VSS 8.62729481385e-16
C11 DI VSS 2.80756163854e-17
C12 DI VSS 1.80532564024e-16
C13 DI VSS 2.11460496159e-16
C14 DI VSS 1.72330109329e-16
C15 DUMMY VSS 3.95129403352e-16
C16 DUMMY VSS 2.58044596648e-16
C17 GB VSS 1.57942938025e-17
C18 GB VSS 1.79615772322e-15
C19 GB VSS 8.27509102026e-16
C20 GB VSS 5.95731664291e-16
C21 GB VSS 1.01534745873e-17
C22 GB VSS 2.5601438383e-16
C23 GB VSS 4.64973623533e-16
C24 GB VSS 3.63298298513e-16
C25 GB VSS 1.46661299595e-17
C26 GB VSS 2.03522325033e-16
C27 GB VSS 1.75283408086e-16
C28 GB VSS 1.63515573115e-16
C29 GP VSS 1.52306847527e-17
C30 GP VSS 1.17626717957e-15
C31 GP VSS 9.79116277339e-18
C32 GP VSS 2.26250041168e-16
C33 GP VSS 4.19401755683e-16
C34 GP VSS 1.41428035675e-17
C35 GP VSS 3.28430099667e-16
C36 GP VSS 1.67766272819e-16
C37 OUT VSS 1.66681500308e-17
C38 OUT VSS 1.98925017131e-15
C39 OUT VSS 8.04463200934e-16
C40 OUT VSS 4.38188477724e-16
C41 VDD VSS 1.22301927727e-17
C42 VDD VSS 2.51334193686e-15
C43 VDD VSS 6.32825445978e-16
C44 VDD VSS 1.88760992007e-15
C45 VDD VSS 7.8277148813e-16
C46 VDD VSS 4.11308387181e-16
C47 VDD VSS 7.8277148813e-16
C48 VDD VSS 4.30631140884e-16
C49 VX VSS 1.6250393282e-17
C50 VX VSS 8.95073953304e-16
C51 VX VSS 4.39911429888e-16
C52 VX VSS 6.71219681741e-16
C53 VX VSS 2.21572270893e-16
C54 VX VSS 2.21572270893e-16
C55 GB DUMMY 1.6528e-16
C56 GP VX 1.35789e-16
C57 VX BIAS 2.54311e-16
C58 VDD VX 2.33108e-19
C59 GB GP 8.33624e-16
C60 OUT VX 3.98682e-16
C61 GB BIAS 8.65391e-17
C62 GP DUMMY 7.04415e-18
C63 VDD GB 1.55591e-15
C64 DUMMY BIAS 8.48834e-19
C65 GB OUT 6.42302e-17
C66 OUT DUMMY 2.66754e-19
C67 VDD GP 9.19938e-16
C68 DI GB 6.58538e-17
C69 GP OUT 1.34695e-16
C70 OUT BIAS 2.11911e-16
C71 VDD OUT 5.99649e-18
C72 DI GP 1.16684e-19
C73 VDD DI 3.50771e-16
C74 GB VX 2.45786e-16
C75 VX DUMMY 4.45424e-16
.ends hs_steering_pvt
