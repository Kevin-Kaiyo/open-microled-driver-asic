* NGSPICE file created from hs_steering_pvt.ext - technology: gf180mcuD

.subckt hs_steering_pvt DATA OUT VSS BIAS DUMMY
X0 VSS a_684_3900# a_3084_3900# VSS pfet_03v3 ad=0.88p pd=4.88u as=0.88p ps=4.88u w=2u l=0.28u
X1 a_n1100_4414# DATA VSS ppolyf_u_1k_6p0 r_width=1u r_length=58u
X2 a_5628_3900# a_3084_3900# OUT VSS nfet_03v3 ad=0.44p pd=2.88u as=0.44p ps=2.88u w=1u l=0.28u
X3 VSS a_684_3900# a_3084_3900# VSS nfet_03v3 ad=0.44p pd=2.88u as=0.44p ps=2.88u w=1u l=0.28u
X4 VSS a_n1100_4414# a_684_3900# VSS nfet_03v3 ad=0.44p pd=2.88u as=0.44p ps=2.88u w=1u l=0.28u
X5 a_5628_3900# a_684_3900# DUMMY VSS nfet_03v3 ad=0.44p pd=2.88u as=0.44p ps=2.88u w=1u l=0.28u
X6 VSS BIAS OUT VSS nfet_03v3 ad=0.88p pd=4.88u as=0.88p ps=4.88u w=2u l=1u
X7 VSS a_n1100_4414# a_684_3900# VSS pfet_03v3 ad=0.88p pd=4.88u as=0.88p ps=4.88u w=2u l=0.28u
X8 VSS BIAS a_5628_3900# VSS nfet_03v3 ad=2.5344p pd=12.4u as=2.5344p ps=12.4u w=5.76u l=1u
X9 VSS BIAS BIAS VSS nfet_03v3 ad=0.88p pd=4.88u as=0.88p ps=4.88u w=2u l=1u
.ends
