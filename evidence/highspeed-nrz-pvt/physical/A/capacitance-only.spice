* Explicit control derived from full raw RC; original RC retained.
.subckt hs_voltage_pvt DATA OUT VDD VH VL VSS
X0 VL CTRL OUT VSS nfet_03v3 ad=1.76p pd=8.88u as=1.76p ps=8.88u w=4u l=0.28u
X2 VSS N1 CTRL VSS nfet_03v3 ad=1.76p pd=8.88u as=1.76p ps=8.88u w=4u l=0.28u
X3 VSS DI N1 VSS nfet_03v3 ad=0.44p pd=2.88u as=0.44p ps=2.88u w=1u l=0.28u
X4 VH CTRL OUT VH pfet_03v3 ad=3.52p pd=16.88u as=3.52p ps=16.88u w=8u l=0.28u
X5 VDD DI N1 VDD pfet_03v3 ad=0.88p pd=4.88u as=0.88p ps=4.88u w=2u l=0.28u
X6 VDD N1 CTRL VDD pfet_03v3 ad=3.52p pd=16.88u as=3.52p ps=16.88u w=8u l=0.28u
X1 DI DATA VSS ppolyf_u_1k_6p0 r_width=1u r_length=48u
C0 CTRL VSS 1.27462161533e-17
C1 CTRL VSS 1.44142884651e-15
C2 CTRL VSS 4.36033675197e-16
C3 CTRL VSS 3.27759989218e-17
C4 CTRL VSS 3.40755353525e-16
C5 CTRL VSS 3.22484149948e-16
C6 CTRL VSS 6.62398501338e-16
C7 CTRL VSS 4.73430304591e-17
C8 CTRL VSS 2.39517814791e-16
C9 CTRL VSS 1.65136413155e-16
C10 DATA VSS 5.13794e-16
C11 DI VSS 6.62186309707e-16
C12 DI VSS 8.51641209693e-16
C13 DI VSS 2.77146583814e-17
C14 DI VSS 1.78211737841e-16
C15 DI VSS 2.08741728168e-16
C16 DI VSS 1.7011435621e-16
C17 N1 VSS 1.54463479187e-17
C18 N1 VSS 1.83969729712e-15
C19 N1 VSS 5.82606952591e-16
C20 N1 VSS 9.92979151611e-18
C21 N1 VSS 2.50374515093e-16
C22 N1 VSS 4.54729908403e-16
C23 N1 VSS 3.55295377102e-16
C24 N1 VSS 1.43430433105e-17
C25 N1 VSS 2.93669654498e-16
C26 N1 VSS 2.04417112445e-16
C27 OUT VSS 7.88274535804e-18
C28 OUT VSS 6.42674893131e-16
C29 OUT VSS 5.96091292881e-16
C30 OUT VSS 3.79931068631e-16
C31 VDD VSS 1.13952037026e-17
C32 VDD VSS 3.05531299613e-15
C33 VDD VSS 5.89620089804e-16
C34 VDD VSS 1.75873530104e-15
C35 VDD VSS 7.29328258846e-16
C36 VDD VSS 3.8322569002e-16
C37 VDD VSS 2.23923631404e-15
C38 VDD VSS 8.15746146427e-16
C39 VH VSS 1.03332612682e-17
C40 VH VSS 2.57179679079e-15
C41 VH VSS 2.02086268212e-15
C42 VH VSS 7.19837265826e-16
C43 VL VSS 2.6313057413e-16
C44 VL VSS 3.8602042587e-16
C45 VDD CTRL 1.63697e-15
C46 DI N1 7.78643e-17
C47 VH CTRL 6.79013e-16
C48 VDD DI 3.50771e-16
C49 N1 OUT 8.86747e-18
C50 VDD OUT 1.75508e-17
C51 DI CTRL 1.12268e-18
C52 CTRL OUT 4.22408e-16
C53 N1 VL 7.88075e-19
C54 VDD VL 5.89101e-19
C55 VH OUT 1.82361e-15
C56 CTRL VL 1.94772e-16
C57 VH VL 1.16392e-16
C58 VDD N1 1.61801e-15
C59 OUT VL 7.11607e-16
C60 N1 CTRL 7.04725e-16
.ends hs_voltage_pvt
