* NGSPICE file created from hs_voltage_pvt.ext - technology: gf180mcuD

.subckt hs_voltage_pvt DATA OUT VDD VH VL VSS
X0 VL CTRL OUT VSS nfet_03v3 ad=1.76p pd=8.88u as=1.76p ps=8.88u w=4u l=0.28u
X1 DI DATA VSS ppolyf_u_1k_6p0 r_width=1u r_length=48u
X2 VSS N1 CTRL VSS nfet_03v3 ad=1.76p pd=8.88u as=1.76p ps=8.88u w=4u l=0.28u
X3 VSS a_764_3764# N1 VSS nfet_03v3 ad=0.44p pd=2.88u as=0.44p ps=2.88u w=1u l=0.28u
X4 VH CTRL OUT VH pfet_03v3 ad=3.52p pd=16.88u as=3.52p ps=16.88u w=8u l=0.28u
X5 VDD DI N1 VDD pfet_03v3 ad=0.88p pd=4.88u as=0.88p ps=4.88u w=2u l=0.28u
X6 VDD N1 CTRL VDD pfet_03v3 ad=3.52p pd=16.88u as=3.52p ps=16.88u w=8u l=0.28u
.ends
