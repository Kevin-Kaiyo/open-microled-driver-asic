* NGSPICE file created from hs_voltage_pvt.ext - technology: gf180mcuD

X0 VL CTRL OUT VSS nfet_03v3 ad=1.76p pd=8.88u as=1.76p ps=8.88u w=4u l=0.28u
X1 DI DATA VSS ppolyf_u_1k_6p0 r_width=1u r_length=48u
X2 VSS N1 CTRL VSS nfet_03v3 ad=1.76p pd=8.88u as=1.76p ps=8.88u w=4u l=0.28u
X3 VSS DI N1 VSS nfet_03v3 ad=0.44p pd=2.88u as=0.44p ps=2.88u w=1u l=0.28u
X4 VH CTRL OUT VH pfet_03v3 ad=3.52p pd=16.88u as=3.52p ps=16.88u w=8u l=0.28u
X5 VDD DI N1 VDD pfet_03v3 ad=0.88p pd=4.88u as=0.88p ps=4.88u w=2u l=0.28u
X6 VDD N1 CTRL VDD pfet_03v3 ad=3.52p pd=16.88u as=3.52p ps=16.88u w=8u l=0.28u
C0 VDD OUT 0.01755f
C1 DI VDD 0.35077f
C2 N1 CTRL 0.70472f
C3 CTRL VL 0.19477f
C4 CTRL OUT 0.42241f
C5 N1 VL 0
C6 DI CTRL 0.00112f
C7 N1 OUT 0.00887f
C8 DI N1 0.07786f
C9 OUT VL 0.71161f
C10 CTRL VH 0.67901f
C11 CTRL VDD 1.63697f
C12 VH VL 0.11639f
C13 N1 VDD 1.61801f
C14 VDD VL 0
C15 VH OUT 1.82361f
C16 VL VSS 0.64915f
C17 OUT VSS 1.62658f
C18 DATA VSS 0.51379f
C19 VH VSS 5.32283f
C20 VDD VSS 9.5826f
C21 CTRL VSS 3.70062f ; **FLOATING
C22 N1 VSS 4.02051f ; **FLOATING
C23 DI VSS 2.09861f ; **FLOATING
