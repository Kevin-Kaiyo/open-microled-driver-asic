* C-placement sensitivity control: same full R/MOS, all .ext C at original nets.
.subckt hs_voltage_pvt DATA OUT VDD VH VL VSS
X0 VL.t0 CTRL.t3 OUT.t1 VSS.t5 nfet_03v3 ad=1.76p pd=8.88u as=1.76p ps=8.88u w=4u l=0.28u
X1 DI.t0 DATA.t0 VSS.t0 ppolyf_u_1k_6p0 r_width=1u r_length=48u
X2 VSS.t4 N1.t3 CTRL.t1 VSS.t3 nfet_03v3 ad=1.76p pd=8.88u as=1.76p ps=8.88u w=4u l=0.28u
X3 VSS.t2 DI.t2 N1.t1 VSS.t1 nfet_03v3 ad=0.44p pd=2.88u as=0.44p ps=2.88u w=1u l=0.28u
X4 VH.t1 CTRL.t2 OUT.t0 VH.t0 pfet_03v3 ad=3.52p pd=16.88u as=3.52p ps=16.88u w=8u l=0.28u
X5 VDD.t1 DI.t1 N1.t0 VDD.t0 pfet_03v3 ad=0.88p pd=4.88u as=0.88p ps=4.88u w=2u l=0.28u
X6 VDD.t3 N1.t2 CTRL.t0 VDD.t2 pfet_03v3 ad=3.52p pd=16.88u as=3.52p ps=16.88u w=8u l=0.28u
R0 VL VL.t0 13.6507
R1 OUT.n0 OUT.t0 15.0997
R2 OUT.n0 OUT.t1 14.4133
R3 OUT OUT.n0 0.0905
R4 DATA DATA.t0 16.4663
R5 VH.n0 VH.t0 82.3849
R6 VH.n0 VH.t1 13.8338
R7 VH VH.n0 0.0905
R8 VDD.n2 VDD.t0 146.069
R9 VDD.n0 VDD.t2 82.6691
R10 VDD.n1 VDD.t1 15.1421
R11 VDD.n0 VDD.t3 14.118
R12 VDD.n1 VDD.n0 2.048
R13 VDD.n2 VDD.n1 0.653
R14 VDD VDD.n2 0.0905
R15 VSS.t3 VSS.n2 9896.25
R16 VSS.n13 VSS.n2 6500
R17 VSS.n4 VSS.n3 4146.34
R18 VSS.n10 VSS.n9 3327.76
R19 VSS.n14 VSS.n13 1674.81
R20 VSS.t5 VSS.n2 1589.65
R21 VSS.n13 VSS.n12 583.516
R22 VSS.n21 VSS.n17 518.972
R23 VSS.n21 VSS.n14 518.972
R24 VSS.n15 VSS.n14 518.972
R25 VSS.n23 VSS.n2 516.346
R26 VSS.n12 VSS.t1 311.019
R27 VSS.n10 VSS.t1 311.019
R28 VSS.n3 VSS.t3 311.019
R29 VSS.n9 VSS.t3 311.019
R30 VSS.n23 VSS.n22 272.276
R31 VSS.n4 VSS.t5 139.417
R32 VSS.n22 VSS.t0 103.796
R33 VSS.n16 VSS.n15 86.3505
R34 VSS.n8 VSS.n3 75.9177
R35 VSS.n11 VSS.n10 47.3183
R36 VSS.n6 VSS.t2 16.8674
R37 VSS.n5 VSS.n4 15.2018
R38 VSS.n11 VSS.n0 13.4534
R39 VSS.n5 VSS.t4 13.2764
R40 VSS.n8 VSS.n7 12.8861
R41 VSS.n24 VSS.n1 12.551
R42 VSS.n20 VSS.n18 10.4698
R43 VSS.n20 VSS.n19 10.4698
R44 VSS.n18 VSS.n1 10.4405
R45 VSS.n19 VSS.n1 10.4405
R46 VSS.n24 VSS.n23 6.5462
R47 VSS.n7 VSS.n6 2.048
R48 VSS.n19 VSS.n17 1.3005
R49 VSS.n18 VSS.n14 1.3005
R50 VSS.n17 VSS.n16 1.08199
R51 VSS.n12 VSS.n11 1.0405
R52 VSS.n7 VSS.n5 0.653
R53 VSS.n6 VSS.n0 0.653
R54 VSS.n9 VSS.n8 0.473227
R55 VSS VSS.n24 0.248
R56 VSS.n16 VSS.t0 0.217301
R57 VSS VSS.n0 0.0905
R58 VSS.n22 VSS.n21 0.0490981
R59 VSS.n21 VSS.n20 0.0490981
R60 VSS.n15 VSS.n1 0.0490981
R61 CTRL.n0 CTRL.t2 147.206
R62 CTRL.n0 CTRL.t3 93.2388
R63 CTRL.n4 CTRL.n3 12.2985
R64 CTRL.n1 CTRL.t0 12.0444
R65 CTRL.n1 CTRL.n0 1.4405
R66 CTRL.n4 CTRL.n1 1.3505
R67 CTRL.n3 CTRL.t1 0.41
R68 CTRL.n3 CTRL.n2 0.284
R69 CTRL CTRL.n4 0.068
R70 N1.n0 N1.t2 147.489
R71 N1.n0 N1.t3 93.5231
R72 N1.n4 N1.n3 14.9452
R73 N1.n1 N1.t0 14.0052
R74 N1.n3 N1.t1 1.6385
R75 N1.n1 N1.n0 1.4405
R76 N1.n4 N1.n1 1.3505
R77 N1.n3 N1.n2 1.1345
R78 N1 N1.n4 0.068
R79 DI.n0 DI.t1 65.6516
R80 DI.n0 DI.t2 51.3843
R81 DI DI.t0 14.958
R82 DI.t0 DI.n1 5.98411
R83 DI DI.n0 0.068
C0 CTRL VSS 3.7006199999999998e-15
C1 DATA VSS 5.1379399999999998e-16
C2 DI VSS 2.0986100000000004e-15
C3 N1 VSS 4.0205100000000003e-15
C4 OUT VSS 1.6265800000000001e-15
C5 VDD VSS 9.5826000000000007e-15
C6 VH VSS 5.3228300000000005e-15
C7 VL VSS 6.4915100000000002e-16
C8 VDD CTRL 1.6369700000000001e-15
C9 DI N1 7.7864300000000012e-17
C10 VH CTRL 6.7901300000000011e-16
C11 VDD DI 3.5077100000000005e-16
C12 N1 OUT 8.8674700000000008e-18
C13 VDD OUT 1.7550800000000001e-17
C14 DI CTRL 1.1226799999999999e-18
C15 CTRL OUT 4.2240800000000006e-16
C16 N1 VL 7.8807500000000004e-19
C17 VDD VL 5.89101e-19
C18 VH OUT 1.8236100000000001e-15
C19 CTRL VL 1.9477200000000002e-16
C20 VH VL 1.1639200000000001e-16
C21 VDD N1 1.61801e-15
C22 OUT VL 7.1160699999999999e-16
C23 N1 CTRL 7.0472500000000003e-16
.ends hs_voltage_pvt
