* Actual common GDS, output12 + analog six MOS; ideal PG, external neighbor boundary.
* Replaces old buffer schematic, digital SPEF, link RC and analog RC together.
.subckt output_pixel_pex I VDD VSS BIAS LED_K GATE PWM_B PWM_DRIVE PWM_MON PWM NBR_00 NBR_01 NBR_02 NBR_03 NBR_04 NBR_05 NBR_06 NBR_07 NBR_08 NBR_09 NBR_10 NBR_11 NBR_12 NBR_13 NBR_14 NBR_15 NBR_16 NBR_17 NBR_18 NBR_19 NBR_20 NBR_21 NBR_22 NBR_23 NBR_24 NBR_25 NBR_26 NBR_27 NBR_28 NBR_29 NBR_30 NBR_31 NBR_32 NBR_33
X0 a_31734_21868.t0 DRIVER_I.t2 VDD VDD pfet_05v0 ad=0.5368p pd=3.32u as=0.4941p ps=2.03u w=1.22u l=0.5u
X1 VDD a_31734_21868.t2 ANALOG_PWM.t3 VDD pfet_05v0 ad=0.4941p pd=2.03u as=0.3782p ps=1.84u w=1.22u l=0.5u
X2 ANALOG_PWM.t0 a_31734_21868.t3 VDD VDD pfet_05v0 ad=0.3782p pd=1.84u as=0.5368p ps=3.32u w=1.22u l=0.5u
X3 a_31734_21868.t1 DRIVER_I.t3 VSS VSS nfet_05v0 ad=0.3608p pd=2.52u as=0.2911p ps=1.53u w=0.82u l=0.6u
X4 VSS a_31734_21868.t4 ANALOG_PWM.t1 VSS nfet_05v0 ad=0.2911p pd=1.53u as=0.2132p ps=1.34u w=0.82u l=0.6u
X5 ANALOG_PWM.t2 a_31734_21868.t5 VSS VSS nfet_05v0 ad=0.2132p pd=1.34u as=0.3608p ps=2.52u w=0.82u l=0.6u
X6 VDD ANALOG_PWM.t4 pwm_b.t0 VDD pfet_06v0 ad=1.76p pd=8.88u as=1.76p ps=8.88u w=4u l=1u
X7 VSS ANALOG_PWM.t5 pwm_b.t1 VSS nfet_06v0 ad=0.88p pd=4.88u as=0.88p ps=4.88u w=2u l=1u
X8 VSS pwm_b.t2 gate.t0 VSS nfet_06v0 ad=0.88p pd=4.88u as=0.88p ps=4.88u w=2u l=1u
X9 gate.t1 ANALOG_PWM.t6 bias.t0 VSS nfet_06v0 ad=0.88p pd=4.88u as=0.88p ps=4.88u w=2u l=1u
X10 VSS gate.t2 led_k.t0 VSS nfet_06v0 ad=8.8p pd=40.88u as=8.8p ps=40.88u w=20u l=4u
X11 VSS bias.t1 bias.t2 VSS nfet_06v0 ad=8.8p pd=40.88u as=8.8p ps=40.88u w=20u l=4u
R35 I DRIVER_I.n0 3.48424
R36 DRIVER_I.n1 DRIVER_I.t2 2.3455
R37 DRIVER_I.n1 DRIVER_I.t3 1.74217
R38 DRIVER_I.n0 DRIVER_I.t0 0.674765
R39 DRIVER_I.n0 DRIVER_I.t1 0.218107
R40 I DRIVER_I.n1 0.0668816
R47 PWM_B pwm_b.n1 6.96717
R48 pwm_b.n0 pwm_b.t0 4.2379
R49 pwm_b.n1 pwm_b.t2 3.3097
R50 pwm_b.n0 pwm_b.t1 2.4029
R51 pwm_b.n1 pwm_b.n0 1.80423
R52 ANALOG_PWM.n3 ANALOG_PWM.t6 7.4897
R53 PWM_MON ANALOG_PWM.n2 6.12936
R54 ANALOG_PWM.n4 ANALOG_PWM.t4 4.4997
R55 ANALOG_PWM.n3 ANALOG_PWM.t5 3.6897
R56 ANALOG_PWM.n4 ANALOG_PWM.n3 1.9005
R57 PWM ANALOG_PWM.n4 1.26463
R58 PWM_MON PWM 0.681605
R59 ANALOG_PWM.n2 ANALOG_PWM.n0 0.33419
R60 ANALOG_PWM.n0 ANALOG_PWM.t2 0.317573
R61 ANALOG_PWM.n0 ANALOG_PWM.t1 0.317573
R62 ANALOG_PWM.n1 ANALOG_PWM.t3 0.295582
R63 ANALOG_PWM.n2 PWM_DRIVE 0.278181
R64 ANALOG_PWM.n1 ANALOG_PWM.t0 0.213615
R65 PWM_DRIVE ANALOG_PWM.n1 0.127987
R78 LED_K led_k.t0 5.9263
R79 gate.n0 gate.t0 4.87037
R80 gate.n1 gate.t2 4.7897
R81 GATE gate.n1 3.16717
R82 gate.n0 gate.t1 3.1629
R83 gate.n1 gate.n0 1.99677
R84 bias.n0 bias.t0 7.24663
R85 bias.n0 bias.t1 5.1697
R86 bias.n1 bias.t2 4.5659
R87 BIAS bias.n1 0.9809
R88 bias.n1 bias.n0 0.286767
R17019 a_31734_21868.n1 a_31734_21868.t3 2.4405
R17020 a_31734_21868.n0 a_31734_21868.t2 2.4405
R17021 a_31734_21868.n1 a_31734_21868.t5 1.61717
R17022 a_31734_21868.n0 a_31734_21868.t4 1.61717
R17023 a_31734_21868.n2 a_31734_21868.n1 1.30606
R17024 a_31734_21868.n3 a_31734_21868.n2 0.827246
R17025 a_31734_21868.n3 a_31734_21868.t1 0.814878
R17026 a_31734_21868.t0 a_31734_21868.n3 0.319354
R17027 a_31734_21868.n2 a_31734_21868.n0 0.139389
C0 ANALOG_PWM.n0 VSS 4.459000000000e-17
C1 ANALOG_PWM.n1 VSS 5.796000000000e-17
C2 ANALOG_PWM.n2 VSS 6.931500000000e-16
C3 ANALOG_PWM.n3 VSS 3.657280000000e-15
C4 ANALOG_PWM.n4 VSS 1.236240000000e-15
C5 ANALOG_PWM.t0 VSS 9.436000000000e-17
C6 ANALOG_PWM.t1 VSS 8.330000000000e-17
C7 ANALOG_PWM.t2 VSS 8.330000000000e-17
C8 ANALOG_PWM.t3 VSS 1.006100000000e-16
C9 BIAS GATE 2.133570000000e-15
C10 BIAS LED_K 2.465600000000e-16
C11 BIAS PWM 1.334920000000e-15
C12 BIAS PWM_B 2.466600000000e-16
C13 BIAS VDD 4.046200000000e-16
C14 BIAS VSS 1.123067000000e-14
C15 DRIVER_I.n0 VSS 1.004510000000e-15
C16 DRIVER_I.n1 VSS 3.130400000000e-16
C17 DRIVER_I.t0 VSS 4.890900000000e-16
C18 DRIVER_I.t1 VSS 4.756000000000e-17
C19 GATE LED_K 1.355960000000e-15
C20 GATE PWM 3.108580000000e-15
C21 GATE PWM_B 1.178500000000e-15
C22 GATE VDD 4.186600000000e-16
C23 GATE VSS 8.308050000000e-15
C24 I NBR_01 2.710000000000e-18
C25 I NBR_02 2.513000000000e-17
C26 I NBR_03 1.748000000000e-17
C28 I NBR_06 1.469000000000e-17
C29 I NBR_07 1.898000000000e-17
C31 I NBR_09 4.820000000000e-17
C32 I NBR_10 1.640000000000e-18
C33 I NBR_11 2.905000000000e-17
C34 I NBR_12 1.160000000000e-18
C35 I NBR_13 1.344300000000e-16
C36 I NBR_14 2.530000000000e-18
C37 I NBR_15 1.508000000000e-17
C40 I NBR_18 3.982000000000e-17
C41 I NBR_19 1.841000000000e-17
C42 I NBR_20 3.920000000000e-18
C43 I NBR_21 4.840000000000e-18
C51 I NBR_29 1.151000000000e-17
C53 I PWM 2.027000000000e-17
C54 I VDD 5.152400000000e-16
C55 I VSS 1.193770000000e-15
C56 LED_K PWM 2.044300000000e-16
C57 LED_K PWM_B 1.984340000000e-15
C58 LED_K VDD 2.327190000000e-15
C59 LED_K VSS 6.967120000000e-15
C61 NBR_02 PWM 1.550000000000e-18
C64 NBR_30 PWM 3.114600000000e-16
C65 NBR_31 PWM 3.847000000000e-17
C67 PWM PWM_B 3.829640000000e-15
C68 PWM VDD 1.841220000000e-15
C69 PWM VSS 8.722760000000e-15
C70 PWM_B VDD 1.017020000000e-15
C71 PWM_B VSS 6.934250000000e-15
C72 PWM_DRIVE VSS 5.588000000000e-17
C73 PWM_MON VSS 1.255780000000e-15
C74 VSS a_31734_21868.n0 1.376400000000e-16
C75 VSS a_31734_21868.n1 1.540000000000e-16
C76 VSS a_31734_21868.n2 1.640300000000e-16
C77 VSS a_31734_21868.n3 2.379600000000e-16
C78 VSS a_31734_21868.t0 1.708300000000e-16
C79 VSS a_31734_21868.t1 1.861500000000e-16
C80 VSS bias.n0 1.144690000000e-15
C81 VSS bias.n1 1.919800000000e-16
C82 VSS bias.t0 1.902490000000e-15
C83 VSS bias.t2 1.363960000000e-15
C84 VSS gate.n0 1.651540000000e-15
C85 VSS gate.n1 1.400550000000e-15
C86 VSS gate.t0 1.026810000000e-15
C87 VSS gate.t1 1.444270000000e-15
C88 VSS led_k.t0 5.268110000000e-15
C89 VSS pwm_b.n0 1.969780000000e-15
C90 VSS pwm_b.n1 2.529890000000e-15
C91 VSS pwm_b.t0 1.481310000000e-15
C92 VSS pwm_b.t1 6.500900000000e-16
.ends output_pixel_pex
