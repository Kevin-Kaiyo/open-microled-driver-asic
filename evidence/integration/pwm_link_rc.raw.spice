* NGSPICE file created from pwm_link_rc.ext - technology: gf180mcuD

.subckt pwm_link_rc A Y VDD VSS
R0 A Y 4.81871
C0 VDD Y 0.14237f
C1 Y VSS 0.02842f
C2 VDD VSS 0.31819f
C3 VSS w_5130_11396# 12.08291f
C4 Y w_5130_11396# 2.08991f
C5 A w_5130_11396# 0.08534f
C6 VDD w_5130_11396# 13.36146f
.ends
