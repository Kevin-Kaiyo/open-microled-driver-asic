* NGSPICE file created from startup_test_macro.ext - technology: gf180mcuD

.subckt startup_test_macro VSS VREF VSAFE VBUF LED_A RAW_PWM FAULT PERMIT VSET SENSE
+ PB N2 CTRL FAULT_HB LED_K REFOUT BIAS GATE PWM_B SAFE_OUT PWM_DRIVE
X0 VSS.t33 a_128036_20068.t2 PWM_DRIVE.t0 VSS.t32 nfet_05v0 ad=0.3608p pd=2.52u as=0.2132p ps=1.34u w=0.82u l=0.6u
X1 VSS.t24 R_N1.t1 R_N1.t2 VSS.t23 nfet_06v0 ad=22p pd=0.10088m as=22p ps=0.10088m w=50u l=10u
X2 VSS.t6 SAFE_OUT.t2 a_128036_20068.t1 VSS.t5 nfet_05v0 ad=0.2911p pd=1.53u as=0.3608p ps=2.52u w=0.82u l=0.6u
X3 VSS.t12 FAULT.t3 BIAS.t2 VSS.t11 nfet_06v0 ad=0.88p pd=4.88u as=0.88p ps=4.88u w=2u l=1u
X4 VSAFE.t3 RAW_PWM.t1 F_NAND_N.t1 VSAFE.t2 pfet_06v0 ad=1.76p pd=8.88u as=1.76p ps=8.88u w=4u l=1u
X5 VSS.t29 F_FAULT_B.t2 F_STACK2.t1 VSS.t28 nfet_06v0 ad=2.64p pd=12.88u as=2.64p ps=12.88u w=6u l=1u
X6 R_TAIL.t0 SENSE.t1 N2.t1 VREF.t6 pfet_06v0 ad=44p pd=0.20088m as=44p ps=0.20088m w=100u l=10u
X7 BIAS.t5 I_FAULT_B.t2 REFOUT.t1 VSS.t25 nfet_06v0 ad=8.8p pd=40.88u as=8.8p ps=40.88u w=20u l=1u
X8 VSAFE.t10 F_FAULT_B.t3 F_NAND_N.t3 VSAFE.t9 pfet_06v0 ad=1.76p pd=8.88u as=1.76p ps=8.88u w=4u l=1u
X9 VSS.t20 BIAS.t3 BIAS.t4 VSS.t19 nfet_06v0 ad=8.8p pd=40.88u as=8.8p ps=40.88u w=20u l=4u
X10 VSS.t31 F_NAND_N.t5 SAFE_OUT.t0 VSS.t30 nfet_06v0 ad=1.76p pd=8.88u as=1.76p ps=8.88u w=4u l=1u
X11 PWM_DRIVE.t3 a_128036_20068.t5 VBUF.t7 VBUF.t6 pfet_05v0 ad=0.3782p pd=1.84u as=0.4941p ps=2.03u w=1.22u l=0.5u
X12 VSS.t14 FAULT.t0 FAULT_HB.t0 VSS.t13 nfet_06v0 ad=0.88p pd=4.88u as=0.88p ps=4.88u w=2u l=1u
X13 GATE.t1 PWM_DRIVE.t6 BIAS.t0 VSS.t2 nfet_06v0 ad=0.88p pd=4.88u as=0.88p ps=4.88u w=2u l=1u
X14 VBUF.t1 PWM_DRIVE.t4 PWM_B.t0 VBUF.t0 pfet_06v0 ad=1.76p pd=8.88u as=1.76p ps=8.88u w=4u l=1u
X15 VSS.t18 FAULT.t5 I_FAULT_B.t1 VSS.t17 nfet_06v0 ad=0.88p pd=4.88u as=0.88p ps=4.88u w=2u l=1u
X16 VREF.t5 CTRL.t4 SENSE.t0 VREF.t4 pfet_06v0 ad=44p pd=0.20088m as=44p ps=0.20088m w=100u l=10u
X17 VSAFE.t5 FAULT.t4 I_FAULT_B.t0 VSAFE.t4 pfet_06v0 ad=1.76p pd=8.88u as=1.76p ps=8.88u w=4u l=1u
X18 R_TAIL.t1 VSET.t0 R_N1.t0 VREF.t7 pfet_06v0 ad=44p pd=0.20088m as=44p ps=0.20088m w=100u l=10u
X19 VSS.t22 N2.t2 CTRL.t2 VSS.t21 nfet_06v0 ad=8.8p pd=40.88u as=8.8p ps=40.88u w=20u l=1u
X20 REFOUT.t0 FAULT.t6 BIAS.t1 VSAFE.t8 pfet_06v0 ad=8.8p pd=40.88u as=8.8p ps=40.88u w=20u l=1u
X21 VREF.t11 PB.t0 PB.t1 VREF.t10 pfet_06v0 ad=8.8p pd=40.88u as=8.8p ps=40.88u w=20u l=4u
X22 F_STACK1.t1 RAW_PWM.t0 F_NAND_N.t2 VSS.t8 nfet_06v0 ad=2.64p pd=12.88u as=2.64p ps=12.88u w=6u l=1u
X23 VBUF.t3 SAFE_OUT.t3 a_128036_20068.t0 VBUF.t2 pfet_05v0 ad=0.4941p pd=2.03u as=0.5368p ps=3.32u w=1.22u l=0.5u
X24 VBUF.t5 a_128036_20068.t4 PWM_DRIVE.t2 VBUF.t4 pfet_05v0 ad=0.5368p pd=3.32u as=0.3782p ps=1.84u w=1.22u l=0.5u
X25 VSS.t10 GATE.t2 LED_K.t1 VSS.t9 nfet_06v0 ad=8.8p pd=40.88u as=8.8p ps=40.88u w=20u l=4u
X26 VSS.t1 PWM_B.t2 GATE.t0 VSS.t0 nfet_06v0 ad=0.88p pd=4.88u as=0.88p ps=4.88u w=2u l=1u
X27 VREF.t9 PB.t2 R_TAIL.t2 VREF.t8 pfet_06v0 ad=8.8p pd=40.88u as=8.8p ps=40.88u w=20u l=4u
X28 VREF.t1 CTRL.t3 REFOUT.t2 VREF.t0 pfet_06v0 ad=44p pd=0.20088m as=44p ps=0.20088m w=100u l=10u
X29 VSS.t16 FAULT.t2 F_FAULT_B.t1 VSS.t15 nfet_06v0 ad=0.88p pd=4.88u as=0.88p ps=4.88u w=2u l=1u
X30 PWM_DRIVE.t1 a_128036_20068.t3 VSS.t35 VSS.t34 nfet_05v0 ad=0.2132p pd=1.34u as=0.2911p ps=1.53u w=0.82u l=0.6u
X31 VREF.t3 CTRL.t0 CTRL.t1 VREF.t2 pfet_06v0 ad=44p pd=0.20088m as=44p ps=0.20088m w=100u l=10u
X32 VSAFE.t7 FAULT.t1 F_FAULT_B.t0 VSAFE.t6 pfet_06v0 ad=1.76p pd=8.88u as=1.76p ps=8.88u w=4u l=1u
X33 VSAFE.t1 PERMIT.t1 F_NAND_N.t0 VSAFE.t0 pfet_06v0 ad=1.76p pd=8.88u as=1.76p ps=8.88u w=4u l=1u
X34 F_STACK2.t0 PERMIT.t0 F_STACK1.t0 VSS.t7 nfet_06v0 ad=2.64p pd=12.88u as=2.64p ps=12.88u w=6u l=1u
X35 VSAFE.t12 F_NAND_N.t4 SAFE_OUT.t1 VSAFE.t11 pfet_06v0 ad=3.52p pd=16.88u as=3.52p ps=16.88u w=8u l=1u
X36 VSS.t27 R_N1.t3 N2.t0 VSS.t26 nfet_06v0 ad=22p pd=0.10088m as=22p ps=0.10088m w=50u l=10u
X37 LED_A.t1 FAULT_HB.t1 LED_K.t0 LED_A.t0 pfet_06v0 ad=0.88p pd=4.88u as=0.88p ps=4.88u w=2u l=1u
X38 VSS.t4 PWM_DRIVE.t5 PWM_B.t1 VSS.t3 nfet_06v0 ad=0.88p pd=4.88u as=0.88p ps=4.88u w=2u l=1u
R0 PWM_B PWM_B.n1 87.3005
R1 PWM_B.n1 PWM_B.t2 32.3975
R2 PWM_B.n0 PWM_B.t0 23.1465
R3 PWM_B.n0 PWM_B.t1 21.7355
R4 PWM_B.n1 PWM_B.n0 2.5865
R5 PWM_DRIVE PWM_DRIVE.n5 84.6005
R6 PWM_DRIVE.n3 PWM_DRIVE.t4 38.1225
R7 PWM_DRIVE.n5 PWM_DRIVE.t6 31.0475
R8 PWM_DRIVE.n4 PWM_DRIVE.t5 31.0475
R9 PWM_DRIVE.n3 PWM_DRIVE.n2 22.3678
R10 PWM_DRIVE.n2 PWM_DRIVE.n0 6.929
R11 PWM_DRIVE.n5 PWM_DRIVE.n4 5.4005
R12 PWM_DRIVE.n2 PWM_DRIVE.n1 2.81668
R13 PWM_DRIVE.n4 PWM_DRIVE.n3 2.7005
R14 PWM_DRIVE.n1 PWM_DRIVE.t3 2.06607
R15 PWM_DRIVE.n0 PWM_DRIVE.t0 1.99806
R16 PWM_DRIVE.n0 PWM_DRIVE.t1 1.99806
R17 PWM_DRIVE.n1 PWM_DRIVE.t2 1.4923
R18 FAULT_HB FAULT_HB.n0 73.6865
R19 FAULT_HB.n0 FAULT_HB.t1 38.5865
R20 FAULT_HB.n0 FAULT_HB.t0 25.1105
R21 SAFE_OUT SAFE_OUT.n2 68.2865
R22 SAFE_OUT.n1 SAFE_OUT.n0 52.3262
R23 SAFE_OUT.n2 SAFE_OUT.t0 19.8635
R24 SAFE_OUT.n1 SAFE_OUT.t1 19.1999
R25 SAFE_OUT.n0 SAFE_OUT.t3 17.119
R26 SAFE_OUT.n0 SAFE_OUT.t2 12.7147
R27 SAFE_OUT.n2 SAFE_OUT.n1 2.7005
R28 PERMIT.n0 PERMIT.t0 62.0725
R29 PERMIT PERMIT.n0 54.9005
R30 PERMIT.n0 PERMIT.t1 46.8975
R31 RAW_PWM.n0 RAW_PWM.t0 63.4225
R32 RAW_PWM RAW_PWM.n0 52.2005
R33 RAW_PWM.n0 RAW_PWM.t1 48.2475
R34 LED_K LED_K.n0 76.3865
R35 LED_K.n0 LED_K.t1 37.5734
R36 LED_K.n0 LED_K.t0 24.2515
R37 GATE GATE.n1 81.9005
R38 GATE.n1 GATE.t2 47.5895
R39 GATE.n0 GATE.t0 24.8825
R40 GATE.n0 GATE.t1 22.4105
R41 GATE.n1 GATE.n0 2.8145
R42 FAULT.n3 FAULT.t6 114.297
R43 FAULT.n0 FAULT.t0 64.7975
R44 FAULT.n4 FAULT.t4 47.5725
R45 FAULT.n0 FAULT.t1 47.5725
R46 FAULT.n2 FAULT.t3 40.4975
R47 FAULT.n5 FAULT.t5 40.4975
R48 FAULT.n1 FAULT.t2 40.4975
R49 FAULT FAULT.n5 33.3005
R50 FAULT.n4 FAULT.n3 5.4005
R51 FAULT.n2 FAULT.n1 2.7005
R52 FAULT.n1 FAULT.n0 2.7005
R53 FAULT.n5 FAULT.n4 2.7005
R54 FAULT.n3 FAULT.n2 2.7005
R55 BIAS.n0 BIAS.t3 48.2645
R56 BIAS BIAS.n4 38.8145
R57 BIAS.n2 BIAS.n1 34.8755
R58 BIAS.n1 BIAS.t4 31.0484
R59 BIAS.n4 BIAS.t5 31.0484
R60 BIAS.n3 BIAS.t1 31.0313
R61 BIAS.n0 BIAS.t0 28.3715
R62 BIAS.n2 BIAS.t2 23.0855
R63 BIAS.n3 BIAS.n2 2.7005
R64 BIAS.n4 BIAS.n3 2.4725
R65 BIAS.n1 BIAS.n0 0.3395
R66 REFOUT.n0 REFOUT.t0 34.6343
R67 REFOUT.n0 REFOUT.t1 31.7234
R68 REFOUT.n1 REFOUT.t2 31.5341
R69 REFOUT REFOUT.n1 29.2115
R70 REFOUT.n1 REFOUT.n0 9.3755
R71 CTRL.n0 CTRL.t3 62.5889
R72 CTRL.n1 CTRL.t0 59.2889
R73 CTRL.n0 CTRL.t4 59.2889
R74 CTRL.n3 CTRL.t2 33.7484
R75 CTRL.n2 CTRL.t1 33.5591
R76 CTRL CTRL.n3 20.5865
R77 CTRL.n1 CTRL.n0 3.3005
R78 CTRL.n3 CTRL.n2 2.0255
R79 CTRL.n2 CTRL.n1 0.7895
R80 N2.n0 N2.t2 115.011
R81 N2.n0 N2.t0 34.2837
R82 N2.n1 N2.t1 34.2341
R83 N2 N2.n1 10.0115
R84 N2.n1 N2.n0 6.6005
R85 SENSE.n0 SENSE.t1 61.3139
R86 SENSE.n0 SENSE.t0 50.6951
R87 SENSE SENSE.n0 10.8005
R88 VSET VSET.t0 69.4888
R89 PB.n0 PB.t2 55.0145
R90 PB.n0 PB.t0 52.3145
R91 PB.n1 PB.t1 35.0813
R92 PB PB.n1 1.7615
R93 PB.n1 PB.n0 0.3395
R94 VBUF.n2 VBUF.t4 676.269
R95 VBUF.t6 VBUF.t2 505.793
R96 VBUF.t4 VBUF.t6 432.433
R97 VBUF.n4 VBUF.t0 143.601
R98 VBUF VBUF.n4 92.1755
R99 VBUF.n3 VBUF.n2 34.1945
R100 VBUF.n3 VBUF.t1 30.5715
R101 VBUF.n1 VBUF.t5 6.80877
R102 VBUF.n1 VBUF.n0 5.65222
R103 VBUF.n0 VBUF.t3 2.61116
R104 VBUF.n0 VBUF.t7 2.03739
R105 VBUF.n4 VBUF.n3 0.6395
R106 VBUF.n2 VBUF.n1 0.089
R107 LED_A.n0 LED_A.t0 192.633
R108 LED_A LED_A.n0 75.9755
R109 LED_A.n0 LED_A.t1 31.6405
R110 VSAFE.n11 VSAFE.t4 144.275
R111 VSAFE.n8 VSAFE.t6 144.275
R112 VSAFE.n6 VSAFE.t2 144.275
R113 VSAFE.n4 VSAFE.t0 144.275
R114 VSAFE.n2 VSAFE.t9 144.275
R115 VSAFE.n0 VSAFE.t11 101.493
R116 VSAFE.n9 VSAFE.t8 74.6911
R117 VSAFE VSAFE.n11 35.4755
R118 VSAFE.n0 VSAFE.t12 31.3139
R119 VSAFE.n1 VSAFE.t10 31.2465
R120 VSAFE.n10 VSAFE.t5 31.2465
R121 VSAFE.n3 VSAFE.t1 31.2465
R122 VSAFE.n5 VSAFE.t3 31.2465
R123 VSAFE.n7 VSAFE.t7 31.2465
R124 VSAFE.n1 VSAFE.n0 12.8615
R125 VSAFE.n9 VSAFE.n8 8.1005
R126 VSAFE.n10 VSAFE.n9 4.7615
R127 VSAFE.n3 VSAFE.n2 2.0615
R128 VSAFE.n7 VSAFE.n6 2.0615
R129 VSAFE.n5 VSAFE.n4 2.0615
R130 VSAFE.n6 VSAFE.n5 0.6395
R131 VSAFE.n2 VSAFE.n1 0.6395
R132 VSAFE.n4 VSAFE.n3 0.6395
R133 VSAFE.n11 VSAFE.n10 0.6395
R134 VSAFE.n8 VSAFE.n7 0.6395
R135 VREF.n8 VREF.t8 108.678
R136 VREF.n10 VREF.t10 108.678
R137 VREF.n6 VREF.t7 74.9655
R138 VREF.n5 VREF.t6 74.9655
R139 VREF.n4 VREF.t2 74.9655
R140 VREF.n2 VREF.t4 74.9655
R141 VREF.n0 VREF.t0 74.9655
R142 VREF.n0 VREF.t1 42.8981
R143 VREF.n9 VREF.t11 41.1563
R144 VREF.n7 VREF.t9 41.1563
R145 VREF.n3 VREF.t3 40.9841
R146 VREF.n1 VREF.t5 40.9841
R147 VREF.n5 VREF.n4 12.6005
R148 VREF.n6 VREF.n5 3.3005
R149 VREF.n2 VREF.n1 1.9145
R150 VREF.n4 VREF.n3 1.9145
R151 VREF.n9 VREF.n8 1.6865
R152 VREF VREF.n10 1.4255
R153 VREF.n1 VREF.n0 1.3865
R154 VREF.n3 VREF.n2 1.3865
R155 VREF.n7 VREF.n6 1.2365
R156 VREF.n8 VREF.n7 1.0145
R157 VREF.n10 VREF.n9 1.0145
R158 VSS.n61 VSS.n4 16200.5
R159 VSS.n18 VSS.n16 13089.9
R160 VSS.n42 VSS.n41 7452.55
R161 VSS.n48 VSS.n47 7451.68
R162 VSS.n59 VSS.n7 3726.34
R163 VSS.n57 VSS.n9 3725.61
R164 VSS.n60 VSS.n59 3725.61
R165 VSS.n57 VSS.n8 3725.61
R166 VSS.n68 VSS.n1 3724.86
R167 VSS.n17 VSS.n16 2571.46
R168 VSS.n56 VSS.t13 2165.94
R169 VSS.n59 VSS.n57 2155.04
R170 VSS.n67 VSS.n66 1607.22
R171 VSS.n58 VSS.n5 1457.49
R172 VSS.n18 VSS.t32 1089.78
R173 VSS.n57 VSS.n56 869.86
R174 VSS.n61 VSS.t11 733.232
R175 VSS.t7 VSS.n9 733.232
R176 VSS.n42 VSS.t7 733.232
R177 VSS.n47 VSS.t28 733.232
R178 VSS.t11 VSS.n60 733.232
R179 VSS.t28 VSS.n8 733.232
R180 VSS.t32 VSS.t34 722.222
R181 VSS.n58 VSS.n4 654.351
R182 VSS.n51 VSS.t13 560.308
R183 VSS.n67 VSS.n4 499
R184 VSS.n17 VSS.t5 497.925
R185 VSS.n72 VSS.n2 460.865
R186 VSS.n68 VSS.n67 458.969
R187 VSS.n48 VSS.t30 367.012
R188 VSS.n7 VSS.t15 366.914
R189 VSS.n41 VSS.t8 366.125
R190 VSS.n70 VSS.n69 337.632
R191 VSS.n78 VSS.n77 324.086
R192 VSS.t34 VSS.n17 324.031
R193 VSS.n59 VSS.n58 299.61
R194 VSS.n25 VSS.n24 248.653
R195 VSS.n26 VSS.n12 248.653
R196 VSS.n16 VSS.n14 243.031
R197 VSS.n32 VSS.n31 223.853
R198 VSS.n56 VSS.n55 218.232
R199 VSS.n33 VSS.n10 199.054
R200 VSS.n2 VSS.t26 189.5
R201 VSS.n77 VSS.n1 126.121
R202 VSS.n78 VSS.t23 91.8086
R203 VSS.n66 VSS.t25 76.8867
R204 VSS.n5 VSS.t25 76.8867
R205 VSS.t26 VSS.n1 63.378
R206 VSS.n69 VSS.t17 61.8791
R207 VSS.n69 VSS.n68 51.5479
R208 VSS.n55 VSS.t19 49.268
R209 VSS.n10 VSS.t19 49.268
R210 VSS.t9 VSS.n32 49.268
R211 VSS.n33 VSS.t9 49.268
R212 VSS.n79 VSS.n78 47.8157
R213 VSS.n73 VSS.n72 42.0944
R214 VSS.n65 VSS.n64 41.9739
R215 VSS.n35 VSS.n34 41.8839
R216 VSS.n54 VSS.n53 41.8839
R217 VSS.n76 VSS.n75 41.8825
R218 VSS.n36 VSS.t20 41.8484
R219 VSS.n71 VSS.t22 41.8484
R220 VSS.n11 VSS.t10 41.8484
R221 VSS.n74 VSS.t27 41.7087
R222 VSS.n0 VSS.t24 41.7087
R223 VSS.n21 VSS.n20 37.6138
R224 VSS.n21 VSS.t4 33.8855
R225 VSS.n13 VSS.t1 33.8855
R226 VSS.n52 VSS.t14 33.8855
R227 VSS.n39 VSS.t16 33.8855
R228 VSS.n6 VSS.t12 33.8855
R229 VSS.n3 VSS.t18 33.8855
R230 VSS.n41 VSS.n40 33.1827
R231 VSS.n50 VSS.t31 32.6885
R232 VSS.n38 VSS.n7 32.5978
R233 VSS.n49 VSS.n48 32.3251
R234 VSS.n37 VSS.t29 32.2491
R235 VSS.n28 VSS.n27 31.8691
R236 VSS.n30 VSS.n29 31.8691
R237 VSS.n63 VSS.n62 31.8691
R238 VSS.n23 VSS.n22 31.8691
R239 VSS.n46 VSS.n45 31.8545
R240 VSS.n44 VSS.n43 31.8545
R241 VSS.n72 VSS.t21 24.5572
R242 VSS.n26 VSS.t0 24.4689
R243 VSS.n24 VSS.t3 24.4689
R244 VSS.t0 VSS.n25 24.4689
R245 VSS.n14 VSS.t3 24.4689
R246 VSS.n31 VSS.t2 24.4689
R247 VSS.n12 VSS.t2 24.4689
R248 VSS VSS.n79 12.9755
R249 VSS.n40 VSS.n39 12.8615
R250 VSS.n76 VSS.n2 12.246
R251 VSS.n71 VSS.n70 11.9615
R252 VSS.n19 VSS.t33 8.37615
R253 VSS.n20 VSS.n15 6.37859
R254 VSS.n19 VSS.n18 5.49176
R255 VSS.n34 VSS.n32 5.47319
R256 VSS.n54 VSS.n10 5.47319
R257 VSS.n64 VSS.n63 5.4005
R258 VSS.n65 VSS.n5 4.89781
R259 VSS.n64 VSS.n3 4.7615
R260 VSS.n51 VSS.n50 4.7615
R261 VSS.n53 VSS.n52 4.6115
R262 VSS.n15 VSS.t35 2.72794
R263 VSS.n15 VSS.t6 2.72794
R264 VSS.n44 VSS.n40 2.7005
R265 VSS.n29 VSS.n28 2.7005
R266 VSS.n45 VSS.n44 2.7005
R267 VSS.n43 VSS.n9 2.65957
R268 VSS.n47 VSS.n46 2.65957
R269 VSS.n27 VSS.n25 2.64852
R270 VSS.n30 VSS.n12 2.64852
R271 VSS.n62 VSS.n60 2.64852
R272 VSS.n23 VSS.n14 2.64852
R273 VSS.n38 VSS.n6 2.0615
R274 VSS.n49 VSS.n37 2.0615
R275 VSS.n22 VSS.n13 2.0615
R276 VSS.n74 VSS.n73 1.9865
R277 VSS.n75 VSS.n74 1.9145
R278 VSS.n79 VSS.n0 1.9145
R279 VSS.n29 VSS.n11 1.8365
R280 VSS.n36 VSS.n35 1.6865
R281 VSS.n62 VSS.n61 1.45586
R282 VSS.n24 VSS.n23 1.45586
R283 VSS.n27 VSS.n26 1.45586
R284 VSS.n31 VSS.n30 1.45586
R285 VSS.n75 VSS.n0 1.3865
R286 VSS.n35 VSS.n11 1.0145
R287 VSS.n53 VSS.n36 1.0145
R288 VSS.n46 VSS.n8 0.685319
R289 VSS.n43 VSS.n42 0.685319
R290 VSS.n73 VSS.n71 0.6395
R291 VSS.n39 VSS.n38 0.6395
R292 VSS.n45 VSS.n37 0.6395
R293 VSS.n50 VSS.n49 0.6395
R294 VSS.n52 VSS.n51 0.6395
R295 VSS.n28 VSS.n13 0.6395
R296 VSS.n70 VSS.n3 0.6395
R297 VSS.n22 VSS.n21 0.6395
R298 VSS.n63 VSS.n6 0.6395
R299 VSS.n20 VSS.n19 0.35075
R300 VSS.n34 VSS.n33 0.229745
R301 VSS.n55 VSS.n54 0.229745
R302 VSS.n66 VSS.n65 0.229735
R303 VSS.n77 VSS.n76 0.0954664
R304 a_128036_20068.n1 a_128036_20068.t5 17.8125
R305 a_128036_20068.n0 a_128036_20068.t4 17.8125
R306 a_128036_20068.n1 a_128036_20068.t3 11.8022
R307 a_128036_20068.n0 a_128036_20068.t2 11.8022
R308 a_128036_20068.n2 a_128036_20068.n0 9.53106
R309 a_128036_20068.n3 a_128036_20068.t1 8.88697
R310 a_128036_20068.t0 a_128036_20068.n3 4.21752
R311 a_128036_20068.n3 a_128036_20068.n2 3.64621
R312 a_128036_20068.n2 a_128036_20068.n1 1.01439
R313 F_STACK2 F_STACK2.n0 62.8895
R314 F_STACK2.n0 F_STACK2.t1 16.4961
R315 F_STACK2.n0 F_STACK2.t0 14.0241
R316 F_STACK1 F_STACK1.n0 60.1895
R317 F_STACK1.n0 F_STACK1.t0 17.1711
R318 F_STACK1.n0 F_STACK1.t1 14.6991
R319 F_NAND_N F_NAND_N.n4 51.8615
R320 F_NAND_N.n0 F_NAND_N.t4 51.5975
R321 F_NAND_N.n0 F_NAND_N.t5 34.7475
R322 F_NAND_N.n4 F_NAND_N.t1 15.7215
R323 F_NAND_N.n3 F_NAND_N.t0 15.7215
R324 F_NAND_N.n2 F_NAND_N.t3 15.7215
R325 F_NAND_N.n1 F_NAND_N.t2 15.3741
R326 F_NAND_N.n1 F_NAND_N.n0 8.2145
R327 F_NAND_N.n2 F_NAND_N.n1 2.7005
R328 F_NAND_N.n3 F_NAND_N.n2 2.7005
R329 F_NAND_N.n4 F_NAND_N.n3 2.7005
R330 F_FAULT_B.n0 F_FAULT_B.t2 50.5975
R331 F_FAULT_B F_FAULT_B.n2 46.4615
R332 F_FAULT_B.n0 F_FAULT_B.t3 35.4225
R333 F_FAULT_B.n2 F_FAULT_B.t1 17.6855
R334 F_FAULT_B.n1 F_FAULT_B.t0 16.3965
R335 F_FAULT_B.n1 F_FAULT_B.n0 8.2145
R336 F_FAULT_B.n2 F_FAULT_B.n1 2.7005
R337 I_FAULT_B.n0 I_FAULT_B.t2 105.636
R338 I_FAULT_B I_FAULT_B.n1 32.9615
R339 I_FAULT_B.n1 I_FAULT_B.t1 18.3605
R340 I_FAULT_B.n0 I_FAULT_B.t0 17.0715
R341 I_FAULT_B.n1 I_FAULT_B.n0 2.7005
R342 R_N1.n0 R_N1.t3 43.2139
R343 R_N1.n0 R_N1.t1 39.9139
R344 R_N1.n1 R_N1.t2 26.8587
R345 R_N1.n2 R_N1.t0 26.8091
R346 R_N1.n2 R_N1.n1 6.6005
R347 R_N1 R_N1.n2 6.4865
R348 R_N1.n1 R_N1.n0 0.7895
R349 R_TAIL.n0 R_TAIL.t0 30.7841
R350 R_TAIL.n1 R_TAIL.t2 27.6563
R351 R_TAIL.n0 R_TAIL.t1 27.4841
R352 R_TAIL R_TAIL.n1 4.2365
R353 R_TAIL.n1 R_TAIL.n0 3.8285
C0 CTRL SAFE_OUT 0.40013f
C1 SENSE PWM_DRIVE 0.16537f
C2 N2 FAULT_HB 0.21825f
C3 VSET PWM_B 0.08572f
C4 VBUF LED_K 0.25295f
C5 PB GATE 0.23377f
C6 LED_A RAW_PWM 8.26114f
C7 VSET FAULT 0.49652f
C8 F_STACK2 PWM_B 0.20019f
C9 VSAFE PERMIT 5.01788f
C10 N2 REFOUT 0.2179f
C11 SENSE BIAS 0.16537f
C12 VREF SAFE_OUT 0.9946f
C13 R_TAIL FAULT_HB 0.12379f
C14 F_NAND_N LED_K 0.14448f
C15 F_FAULT_B RAW_PWM 0.15242f
C16 R_N1 SAFE_OUT 0.21835f
C17 F_STACK1 GATE 0.21557f
C18 F_STACK2 FAULT 0.41347f
C19 I_FAULT_B PERMIT 0.15242f
C20 R_TAIL REFOUT 0.22637f
C21 N2 CTRL 12.6415f
C22 LED_K PWM_B 0.14448f
C23 RAW_PWM PWM_DRIVE 0.15242f
C24 PERMIT FAULT_HB 0.15242f
C25 VSAFE SENSE 1.03977f
C26 VREF N2 11.9517f
C27 VBUF PB 0.25295f
C28 LED_A VSET 0.16871f
C29 FAULT LED_K 0.48365f
C30 REFOUT PERMIT 0.15242f
C31 BIAS RAW_PWM 0.15242f
C32 F_STACK1 VBUF 0.22641f
C33 F_STACK2 LED_A 0.15938f
C34 R_TAIL CTRL 0.40013f
C35 I_FAULT_B SENSE 0.16443f
C36 R_N1 N2 3.14032f
C37 F_FAULT_B VSET 0.08403f
C38 F_NAND_N PB 0.23064f
C39 F_FAULT_B F_STACK2 1.05097f
C40 F_NAND_N F_STACK1 8.65789f
C41 R_TAIL VREF 23.3595f
C42 R_TAIL R_N1 8.3405f
C43 SENSE FAULT_HB 0.16537f
C44 PB PWM_B 0.23377f
C45 CTRL PERMIT 0.15242f
C46 VSET PWM_DRIVE 0.08572f
C47 N2 SAFE_OUT 0.2179f
C48 VSET BIAS 0.08572f
C49 VSAFE RAW_PWM 5.33395f
C50 F_STACK1 PWM_B 0.19143f
C51 F_STACK2 PWM_DRIVE 0.24859f
C52 VREF PERMIT 1.02927f
C53 SENSE REFOUT 0.16537f
C54 VBUF GATE 0.25295f
C55 PB FAULT 0.49627f
C56 LED_A LED_K 1.01746f
C57 R_N1 PERMIT 0.15242f
C58 F_FAULT_B LED_K 0.14448f
C59 F_NAND_N GATE 0.21557f
C60 F_STACK2 BIAS 0.4452f
C61 F_STACK1 FAULT 0.39304f
C62 I_FAULT_B RAW_PWM 0.15242f
C63 R_TAIL SAFE_OUT 0.21885f
C64 SENSE CTRL 5.75698f
C65 PERMIT SAFE_OUT 0.15242f
C66 RAW_PWM FAULT_HB 0.15242f
C67 LED_K PWM_DRIVE 0.14448f
C68 GATE PWM_B 10.1155f
C69 LED_A PB 0.16871f
C70 VSAFE VSET 1.03977f
C71 VREF SENSE 15.9288f
C72 REFOUT RAW_PWM 0.15242f
C73 BIAS LED_K 0.14857f
C74 FAULT GATE 0.44353f
C75 R_TAIL N2 0.2179f
C76 F_FAULT_B PB 0.23064f
C77 R_N1 SENSE 0.16443f
C78 F_NAND_N VBUF 0.22641f
C79 F_STACK1 LED_A 0.15355f
C80 F_STACK2 VSAFE 1.04173f
C81 I_FAULT_B VSET 0.08403f
C82 F_FAULT_B F_STACK1 0.26057f
C83 I_FAULT_B F_STACK2 0.20019f
C84 CTRL RAW_PWM 0.15242f
C85 PB PWM_DRIVE 0.23377f
C86 VBUF PWM_B 1.31443f
C87 N2 PERMIT 0.15242f
C88 VSET FAULT_HB 0.08572f
C89 SENSE SAFE_OUT 0.16537f
C90 VBUF FAULT 0.25295f
C91 LED_A GATE 0.15355f
C92 VSAFE LED_K 1.03977f
C93 VSET REFOUT 0.08572f
C94 PB BIAS 0.23377f
C95 F_NAND_N PWM_B 0.19143f
C96 VREF RAW_PWM 1.02927f
C97 F_STACK1 PWM_DRIVE 0.23692f
C98 F_STACK2 FAULT_HB 0.12963f
C99 F_NAND_N FAULT 0.39304f
C100 F_STACK2 REFOUT 0.22783f
C101 I_FAULT_B LED_K 0.14448f
C102 R_TAIL PERMIT 0.15242f
C103 F_STACK1 BIAS 0.42769f
C104 R_N1 RAW_PWM 0.15242f
C105 F_FAULT_B GATE 0.21557f
C106 SENSE N2 5.7721f
C107 VSET CTRL 0.08572f
C108 RAW_PWM SAFE_OUT 0.15242f
C109 FAULT PWM_B 0.44353f
C110 GATE PWM_DRIVE 1.78529f
C111 LED_K FAULT_HB 10.4762f
C112 VREF VSET 5.03569f
C113 F_STACK2 CTRL 0.41472f
C114 LED_A VBUF 8.34543f
C115 VSAFE PB 1.03977f
C116 REFOUT LED_K 8.24068f
C117 BIAS GATE 8.75568f
C118 F_FAULT_B VBUF 0.22641f
C119 F_NAND_N LED_A 0.15355f
C120 I_FAULT_B PB 0.23064f
C121 F_STACK1 VSAFE 1.0038f
C122 F_STACK2 VREF 1.02206f
C123 R_TAIL SENSE 5.63257f
C124 R_N1 VSET 5.53842f
C125 I_FAULT_B F_STACK1 0.19143f
C126 R_N1 F_STACK2 0.34054f
C127 F_FAULT_B F_NAND_N 9.36386f
C128 N2 RAW_PWM 0.15242f
C129 LED_A PWM_B 0.15355f
C130 VSET SAFE_OUT 0.08572f
C131 PB FAULT_HB 0.23377f
C132 VBUF PWM_DRIVE 3.87825f
C133 SENSE PERMIT 0.15275f
C134 CTRL LED_K 0.40126f
C135 PB REFOUT 0.23377f
C136 F_FAULT_B PWM_B 0.19143f
C137 VBUF BIAS 0.25295f
C138 VSAFE GATE 1.03864f
C139 LED_A FAULT 0.16981f
C140 VREF LED_K 0.99898f
C141 F_NAND_N PWM_DRIVE 0.23692f
C142 F_STACK2 SAFE_OUT 0.21251f
C143 F_STACK1 FAULT_HB 0.12379f
C144 I_FAULT_B GATE 0.21557f
C145 R_N1 LED_K 0.14448f
C146 F_FAULT_B FAULT 2.62732f
C147 R_TAIL RAW_PWM 0.15242f
C148 F_NAND_N BIAS 0.42769f
C149 F_STACK1 REFOUT 0.21907f
C150 PWM_DRIVE PWM_B 3.34435f
C151 PB CTRL 0.23457f
C152 VSET N2 0.08572f
C153 RAW_PWM PERMIT 0.15275f
C154 LED_K SAFE_OUT 0.14448f
C155 GATE FAULT_HB 0.12379f
C156 BIAS PWM_B 0.44283f
C157 FAULT PWM_DRIVE 0.44353f
C158 VSAFE VBUF 9.19186f
C159 F_STACK1 CTRL 0.40013f
C160 F_STACK2 N2 0.22571f
C161 VREF PB 12.1059f
C162 BIAS FAULT 6.34323f
C163 REFOUT GATE 0.22687f
C164 F_FAULT_B LED_A 0.15355f
C165 R_TAIL VSET 5.55291f
C166 F_NAND_N VSAFE 4.89449f
C167 I_FAULT_B VBUF 0.22641f
C168 F_STACK1 VREF 0.98704f
C169 R_N1 PB 0.23064f
C170 R_N1 F_STACK1 0.32886f
C171 R_TAIL F_STACK2 0.25552f
C172 I_FAULT_B F_NAND_N 0.1924f
C173 VSET PERMIT 8.24422f
C174 CTRL GATE 0.40013f
C175 N2 LED_K 0.2179f
C176 PB SAFE_OUT 0.23377f
C177 SENSE RAW_PWM 0.15242f
C178 VBUF FAULT_HB 0.25295f
C179 LED_A PWM_DRIVE 0.15355f
C180 VSAFE PWM_B 1.03864f
C181 VBUF REFOUT 0.25295f
C182 F_FAULT_B PWM_DRIVE 0.23692f
C183 LED_A BIAS 0.15355f
C184 VREF GATE 0.9946f
C185 VSAFE FAULT 9.9557f
C186 F_NAND_N FAULT_HB 0.12379f
C187 F_STACK1 SAFE_OUT 0.20376f
C188 I_FAULT_B PWM_B 0.19143f
C189 F_STACK2 PERMIT 0.91014f
C190 R_N1 GATE 0.21557f
C191 R_TAIL LED_K 0.14448f
C192 F_FAULT_B BIAS 0.42769f
C193 F_NAND_N REFOUT 0.21907f
C194 I_FAULT_B FAULT 2.88242f
C195 FAULT_HB PWM_B 0.12379f
C196 VSET SENSE 8.17809f
C197 VBUF CTRL 0.25295f
C198 PB N2 8.32687f
C199 GATE SAFE_OUT 0.22336f
C200 REFOUT PWM_B 0.22637f
C201 BIAS PWM_DRIVE 2.00471f
C202 FAULT FAULT_HB 2.85855f
C203 LED_K PERMIT 0.15242f
C204 F_NAND_N CTRL 0.40013f
C205 F_STACK2 SENSE 0.17027f
C206 F_STACK1 N2 0.21696f
C207 VSAFE LED_A 1.09868f
C208 VREF VBUF 1.0299f
C209 REFOUT FAULT 4.45357f
C210 F_NAND_N VREF 0.98704f
C211 I_FAULT_B LED_A 0.15355f
C212 R_N1 VBUF 0.22641f
C213 R_TAIL PB 1.98991f
C214 F_FAULT_B VSAFE 3.4868f
C215 I_FAULT_B F_FAULT_B 8.28517f
C216 R_TAIL F_STACK1 0.24677f
C217 R_N1 F_NAND_N 0.32886f
C218 CTRL PWM_B 0.40013f
C219 PB PERMIT 0.15242f
C220 VSET RAW_PWM 0.15242f
C221 CTRL FAULT 0.49627f
C222 SENSE LED_K 0.16537f
C223 N2 GATE 0.2179f
C224 VBUF SAFE_OUT 0.43829f
C225 VSAFE PWM_DRIVE 1.03077f
C226 VREF PWM_B 0.9946f
C227 LED_A FAULT_HB 3.0695f
C228 VREF FAULT 1.02927f
C229 VSAFE BIAS 3.58239f
C230 I_FAULT_B PWM_DRIVE 0.23692f
C231 R_N1 PWM_B 0.19143f
C232 F_STACK2 RAW_PWM 0.11813f
C233 F_STACK1 PERMIT 1.03381f
C234 LED_A REFOUT 0.15355f
C235 F_FAULT_B FAULT_HB 0.12379f
C236 F_NAND_N SAFE_OUT 2.24542f
C237 F_FAULT_B REFOUT 0.21907f
C238 R_TAIL GATE 0.21557f
C239 I_FAULT_B BIAS 3.49208f
C240 R_N1 FAULT 0.44353f
C241 SAFE_OUT PWM_B 8.29913f
C242 FAULT_HB PWM_DRIVE 0.12379f
C243 VBUF N2 0.25295f
C244 LED_A CTRL 0.16871f
C245 PB SENSE 8.26011f
C246 BIAS FAULT_HB 0.12379f
C247 LED_K RAW_PWM 0.15242f
C248 GATE PERMIT 0.15242f
C249 FAULT SAFE_OUT 0.44353f
C250 REFOUT PWM_DRIVE 0.22637f
C251 F_FAULT_B CTRL 0.40013f
C252 F_NAND_N N2 0.21696f
C253 F_STACK1 SENSE 0.16443f
C254 VREF LED_A 1.02927f
C255 F_STACK2 VSET 0.08694f
C256 REFOUT BIAS 9.86284f
C257 R_N1 LED_A 0.15355f
C258 R_TAIL VBUF 0.22641f
C259 F_FAULT_B VREF 0.98704f
C260 I_FAULT_B VSAFE 1.8604f
C261 R_TAIL F_NAND_N 0.24677f
C262 R_N1 F_FAULT_B 0.32953f
C263 CTRL PWM_DRIVE 0.40013f
C264 N2 PWM_B 0.2179f
C265 N2 FAULT 0.49627f
C266 CTRL BIAS 0.40013f
C267 SENSE GATE 0.16537f
C268 LED_A SAFE_OUT 0.15355f
C269 VSAFE FAULT_HB 1.03977f
C270 VREF PWM_DRIVE 0.9946f
C271 PB RAW_PWM 0.15242f
C272 VSET LED_K 0.08572f
C273 VBUF PERMIT 0.25295f
C274 F_STACK2 LED_K 0.15032f
C275 R_N1 PWM_DRIVE 0.23759f
C276 F_STACK1 RAW_PWM 1.01923f
C277 F_NAND_N PERMIT 1.14842f
C278 F_FAULT_B SAFE_OUT 0.21835f
C279 R_TAIL PWM_B 0.19143f
C280 VSAFE REFOUT 2.68991f
C281 VREF BIAS 0.9946f
C282 I_FAULT_B FAULT_HB 0.12379f
C283 R_TAIL FAULT 0.44353f
C284 I_FAULT_B REFOUT 3.28346f
C285 R_N1 BIAS 0.43499f
C286 SAFE_OUT PWM_DRIVE 8.79135f
C287 PERMIT PWM_B 0.15242f
C288 VBUF SENSE 0.25295f
C289 LED_A N2 0.16871f
C290 VSAFE CTRL 1.03977f
C291 PB VSET 0.08619f
C292 GATE RAW_PWM 0.15242f
C293 FAULT PERMIT 8.58898f
C294 BIAS SAFE_OUT 0.44228f
C295 REFOUT FAULT_HB 0.12428f
C296 F_NAND_N SENSE 0.16443f
C297 I_FAULT_B CTRL 0.40013f
C298 VREF VSAFE 9.12913f
C299 F_STACK2 PB 0.23939f
C300 F_STACK1 VSET 0.08403f
C301 F_FAULT_B N2 0.21696f
C302 F_STACK1 F_STACK2 8.4193f
C303 R_TAIL LED_A 0.15355f
C304 I_FAULT_B VREF 0.98704f
C305 R_N1 VSAFE 1.03077f
C306 R_N1 I_FAULT_B 8.42203f
C307 R_TAIL F_FAULT_B 0.24677f
C308 CTRL FAULT_HB 8.49348f
C309 SENSE PWM_B 0.16537f
C310 N2 PWM_DRIVE 0.2179f
C311 SENSE FAULT 0.49627f
C312 N2 BIAS 0.2179f
C313 VSAFE SAFE_OUT 2.7094f
C314 VREF FAULT_HB 0.99898f
C315 PB LED_K 0.23377f
C316 VBUF RAW_PWM 0.25329f
C317 VSET GATE 0.08572f
C318 LED_A PERMIT 0.16871f
C319 CTRL REFOUT 5.95055f
C320 R_TAIL PWM_DRIVE 8.33009f
C321 VREF REFOUT 11.8056f
C322 I_FAULT_B SAFE_OUT 0.21835f
C323 F_STACK2 GATE 0.22432f
C324 F_STACK1 LED_K 0.14448f
C325 F_FAULT_B PERMIT 0.15242f
C326 F_NAND_N RAW_PWM 2.15736f
C327 R_N1 FAULT_HB 0.12379f
C328 R_N1 REFOUT 0.22637f
C329 R_TAIL BIAS 0.43499f
C330 SAFE_OUT FAULT_HB 0.12379f
C331 RAW_PWM PWM_B 0.15242f
C332 PERMIT PWM_DRIVE 0.15242f
C333 LED_A SENSE 0.16871f
C334 VSAFE N2 1.03977f
C335 VREF CTRL 40.3332f
C336 VBUF VSET 0.25295f
C337 BIAS PERMIT 0.15242f
C338 REFOUT SAFE_OUT 0.22637f
C339 GATE LED_K 2.03666f
C340 FAULT RAW_PWM 8.24796f
C341 R_N1 CTRL 0.40013f
C342 F_STACK2 VBUF 0.23516f
C343 F_NAND_N VSET 0.08403f
C344 F_STACK1 PB 0.23064f
C345 F_FAULT_B SENSE 0.16443f
C346 I_FAULT_B N2 0.21696f
C347 R_TAIL VSAFE 1.03077f
C348 R_N1 VREF 11.5633f
C349 F_NAND_N F_STACK2 0.40077f
C350 R_TAIL I_FAULT_B 0.24727f
C351 PWM_B VSS 33.8244f
C352 PWM_DRIVE VSS 34.1768f
C353 FAULT_HB VSS 29.86525f
C354 SAFE_OUT VSS 31.14479f
C355 PERMIT VSS 30.15194f
C356 RAW_PWM VSS 30.30123f
C357 LED_K VSS 32.62607f
C358 GATE VSS 35.56955f
C359 FAULT VSS 50.11551f
C360 BIAS VSS 43.52649f
C361 REFOUT VSS 33.46932f
C362 CTRL VSS 36.26366f
C363 N2 VSS 37.05668f
C364 SENSE VSS 26.0835f
C365 VSET VSS 34.6135f
C366 PB VSS 26.89522f
C367 VBUF VSS 47.63002f
C368 LED_A VSS 37.01191f
C369 VSAFE VSS 0.1214p
C370 VREF VSS 0.95468p
C371 F_STACK2 VSS 38.11414f
C372 F_STACK1 VSS 26.55454f
C373 F_NAND_N VSS 28.93872f
C374 F_FAULT_B VSS 27.23189f
C375 I_FAULT_B VSS 24.63801f
C376 R_N1 VSS 44.28064f
C377 R_TAIL VSS 28.32006f
C378 R_TAIL.t0 VSS 26.358f
C379 R_TAIL.t1 VSS 19.22396f
C380 R_TAIL.n0 VSS 33.3162f
C381 R_TAIL.t2 VSS 5.57795f
C382 R_TAIL.n1 VSS 2.98872f
C383 R_N1.n0 VSS 12.2563f
C384 R_N1.t2 VSS 7.35787f
C385 R_N1.n1 VSS 0.81176f
C386 R_N1.t0 VSS 13.79597f
C387 R_N1.n2 VSS 1.11128f
C388 I_FAULT_B.t0 VSS 1.15506f
C389 I_FAULT_B.n0 VSS 19.8882f
C390 I_FAULT_B.t1 VSS 1.03815f
C391 I_FAULT_B.n1 VSS 5.4375f
C392 F_FAULT_B.n0 VSS 11.6625f
C393 F_FAULT_B.t0 VSS 1.08659f
C394 F_FAULT_B.n1 VSS 1.84211f
C395 F_FAULT_B.t1 VSS 0.97755f
C396 F_FAULT_B.n2 VSS 6.89549f
C397 F_NAND_N.n0 VSS 10.6634f
C398 F_NAND_N.t2 VSS 1.85586f
C399 F_NAND_N.n1 VSS 1.91587f
C400 F_NAND_N.t3 VSS 0.75519f
C401 F_NAND_N.n2 VSS 1.14967f
C402 F_NAND_N.t0 VSS 0.94438f
C403 F_NAND_N.n3 VSS 1.14967f
C404 F_NAND_N.t1 VSS 0.97006f
C405 F_NAND_N.n4 VSS 8.05052f
C406 F_STACK1.t0 VSS 3.05074f
C407 F_STACK1.t1 VSS 1.73491f
C408 F_STACK1.n0 VSS 16.0351f
C409 F_STACK2.t1 VSS 2.3405f
C410 F_STACK2.t0 VSS 1.4973f
C411 F_STACK2.n0 VSS 10.7308f
C412 a_128036_20068.t1 VSS 0.08216f
C413 a_128036_20068.n0 VSS 0.13559f
C414 a_128036_20068.n1 VSS 0.12119f
C415 a_128036_20068.n2 VSS 0.05183f
C416 a_128036_20068.n3 VSS 0.30493f
C417 a_128036_20068.t0 VSS 0.09929f
C418 VSS.t24 VSS 6.0529f
C419 VSS.t18 VSS 0.55889f
C420 VSS.t12 VSS 0.55889f
C421 VSS.t10 VSS 2.24913f
C422 VSS.t1 VSS 0.27038f
C423 VSS.t35 VSS 0.06374f
C424 VSS.t6 VSS 0.02119f
C425 VSS.t33 VSS 0.06374f
C426 VSS.t4 VSS 0.27495f
C427 VSS.t20 VSS 2.45471f
C428 VSS.t29 VSS 1.11249f
C429 VSS.t16 VSS 0.55889f
C430 VSS.t31 VSS 0.23098f
C431 VSS.t14 VSS 3.13211f
C432 VSS.t22 VSS 1.32057f
C433 VSS.t27 VSS 6.46735f
C434 VREF.t1 VSS 11.69108f
C435 VREF.t0 VSS 20.2221f
C436 VREF.n0 VSS 11.8289f
C437 VREF.t5 VSS 11.17683f
C438 VREF.n1 VSS 0.63009f
C439 VREF.t4 VSS 20.2221f
C440 VREF.n2 VSS 6.56358f
C441 VREF.t3 VSS 11.17683f
C442 VREF.n3 VSS 0.63009f
C443 VREF.t2 VSS 20.2221f
C444 VREF.n4 VSS 6.96536f
C445 VREF.t6 VSS 20.2221f
C446 VREF.n5 VSS 7.01502f
C447 VREF.t7 VSS 20.2221f
C448 VREF.n6 VSS 6.60787f
C449 VREF.t9 VSS 3.60297f
C450 VREF.n7 VSS 0.59463f
C451 VREF.t8 VSS 2.21353f
C452 VREF.n8 VSS 2.19317f
C453 VREF.t11 VSS 3.07351f
C454 VREF.n9 VSS 0.61075f
C455 VREF.t10 VSS 2.21353f
C456 VREF.n10 VSS 2.18381f
C457 VSAFE.t12 VSS 2.09946f
C458 VSAFE.t11 VSS 1.92206f
C459 VSAFE.n0 VSS 12.5583f
C460 VSAFE.t10 VSS 1.44292f
C461 VSAFE.n1 VSS 2.69074f
C462 VSAFE.t9 VSS 1.11033f
C463 VSAFE.n2 VSS 3.43079f
C464 VSAFE.t1 VSS 1.63212f
C465 VSAFE.n3 VSS 1.4444f
C466 VSAFE.t0 VSS 1.11033f
C467 VSAFE.n4 VSS 3.43079f
C468 VSAFE.t3 VSS 1.6578f
C469 VSAFE.n5 VSS 1.4444f
C470 VSAFE.t2 VSS 1.11033f
C471 VSAFE.n6 VSS 3.43079f
C472 VSAFE.t7 VSS 1.76988f
C473 VSAFE.n7 VSS 1.4444f
C474 VSAFE.t6 VSS 1.11033f
C475 VSAFE.n8 VSS 4.1277f
C476 VSAFE.t8 VSS 5.35457f
C477 VSAFE.n9 VSS 5.84768f
C478 VSAFE.t5 VSS 1.76988f
C479 VSAFE.n10 VSS 1.75599f
C480 VSAFE.t4 VSS 1.11033f
C481 VSAFE.n11 VSS 7.28684f
C482 LED_A.t1 VSS 1.689f
C483 LED_A.t0 VSS 0.64772f
C484 LED_A.n0 VSS 16.3433f
C485 VBUF.t2 VSS 0.26225f
C486 VBUF.t6 VSS 0.16298f
C487 VBUF.t4 VSS 0.1936f
C488 VBUF.t5 VSS 0.09242f
C489 VBUF.t7 VSS 0.08001f
C490 VBUF.t3 VSS 0.03608f
C491 VBUF.n0 VSS 0.03133f
C492 VBUF.n1 VSS 0.14748f
C493 VBUF.n2 VSS 1.57114f
C494 VBUF.t1 VSS 1.35924f
C495 VBUF.n3 VSS 3.22166f
C496 VBUF.t0 VSS 0.9817f
C497 VBUF.n4 VSS 12.3667f
C498 PB.n0 VSS 22.7243f
C499 PB.t1 VSS 4.19177f
C500 PB.n1 VSS 1.40676f
C501 SENSE.t0 VSS 16.24454f
C502 SENSE.n0 VSS 16.4173f
C503 N2.t0 VSS 10.53376f
C504 N2.n0 VSS 28.5373f
C505 N2.t1 VSS 21.57459f
C506 N2.n1 VSS 4.04357f
C507 CTRL.n0 VSS 13.8404f
C508 CTRL.n1 VSS 4.08767f
C509 CTRL.t1 VSS 11.42272f
C510 CTRL.n2 VSS 0.60749f
C511 CTRL.t2 VSS 2.09786f
C512 CTRL.n3 VSS 1.48147f
C513 REFOUT.t0 VSS 5.50879f
C514 REFOUT.t1 VSS 3.6983f
C515 REFOUT.n0 VSS 22.9782f
C516 REFOUT.t2 VSS 16.8521f
C517 REFOUT.n1 VSS 7.94541f
C518 BIAS.t0 VSS 1.75354f
C519 BIAS.n0 VSS 6.292f
C520 BIAS.t4 VSS 4.30628f
C521 BIAS.n1 VSS 5.06864f
C522 BIAS.t2 VSS 1.17081f
C523 BIAS.n2 VSS 4.88338f
C524 BIAS.t1 VSS 2.84046f
C525 BIAS.n3 VSS 1.68911f
C526 BIAS.t5 VSS 2.81379f
C527 BIAS.n4 VSS 5.75157f
C528 FAULT.n0 VSS 14.7117f
C529 FAULT.n1 VSS 2.58607f
C530 FAULT.n2 VSS 2.58607f
C531 FAULT.n3 VSS 4.71305f
C532 FAULT.n4 VSS 3.14923f
C533 FAULT.n5 VSS 7.42005f
C534 GATE.t0 VSS 1.14348f
C535 GATE.t1 VSS 0.8097f
C536 GATE.n0 VSS 4.18923f
C537 GATE.n1 VSS 10.4845f
C538 LED_K.t1 VSS 5.03497f
C539 LED_K.t0 VSS 1.32875f
C540 LED_K.n0 VSS 15.2717f
C541 RAW_PWM.n0 VSS 19.457f
C542 PERMIT.n0 VSS 19.0792f
C543 SAFE_OUT.n0 VSS 2.71088f
C544 SAFE_OUT.t1 VSS 1.40636f
C545 SAFE_OUT.n1 VSS 6.39195f
C546 SAFE_OUT.t0 VSS 0.90431f
C547 SAFE_OUT.n2 VSS 9.27438f
C548 FAULT_HB.t0 VSS 3.96302f
C549 FAULT_HB.n0 VSS 18.005f
C550 PWM_DRIVE.t0 VSS 0.07142f
C551 PWM_DRIVE.t1 VSS 0.07142f
C552 PWM_DRIVE.n0 VSS 0.01762f
C553 PWM_DRIVE.t2 VSS 0.08022f
C554 PWM_DRIVE.t3 VSS 0.08462f
C555 PWM_DRIVE.n1 VSS 0.02877f
C556 PWM_DRIVE.n2 VSS 1.07039f
C557 PWM_DRIVE.n3 VSS 3.55508f
C558 PWM_DRIVE.n4 VSS 2.00819f
C559 PWM_DRIVE.n5 VSS 13.8141f
C560 PWM_B.t0 VSS 1.35959f
C561 PWM_B.t1 VSS 0.89503f
C562 PWM_B.n0 VSS 3.77503f
C563 PWM_B.n1 VSS 12.2851f
.ends
