* NGSPICE file created from startup_test_macro.ext - technology: gf180mcuD

.subckt startup_test_macro VSS VREF VSAFE VBUF LED_A RAW_PWM FAULT PERMIT VSET SENSE
+ PB N2 CTRL FAULT_HB LED_K REFOUT BIAS GATE PWM_B SAFE_OUT PWM_DRIVE
X0 VSS.t33 a_128036_20068.t2 PWM_DRIVE.t0 VSS.t32 nfet_05v0 ad=0.3608p pd=2.52u as=0.2132p ps=1.34u w=0.82u l=0.6u
X1 VSS.t24 R_N1.t1 R_N1.t2 VSS.t23 nfet_06v0 ad=22p pd=0.10088m as=22p ps=0.10088m w=50u l=10u
X2 VSS.t6 SAFE_OUT.t2 a_128036_20068.t1 VSS.t5 nfet_05v0 ad=0.2911p pd=1.53u as=0.3608p ps=2.52u w=0.82u l=0.6u
X3 VSS.t12 FAULT.t3 BIAS.t1 VSS.t11 nfet_06v0 ad=0.88p pd=4.88u as=0.88p ps=4.88u w=2u l=1u
X4 VSAFE.t3 RAW_PWM.t1 F_NAND_N.t1 VSAFE.t2 pfet_06v0 ad=1.76p pd=8.88u as=1.76p ps=8.88u w=4u l=1u
X5 VSS.t29 F_FAULT_B.t2 F_STACK2.t1 VSS.t28 nfet_06v0 ad=2.64p pd=12.88u as=2.64p ps=12.88u w=6u l=1u
X6 R_TAIL.t0 SENSE.t1 N2.t1 VREF.t6 pfet_06v0 ad=44p pd=0.20088m as=44p ps=0.20088m w=100u l=10u
X7 BIAS.t5 I_FAULT_B.t2 REFOUT.t1 VSS.t25 nfet_06v0 ad=8.8p pd=40.88u as=8.8p ps=40.88u w=20u l=1u
X8 VSAFE.t10 F_FAULT_B.t3 F_NAND_N.t3 VSAFE.t9 pfet_06v0 ad=1.76p pd=8.88u as=1.76p ps=8.88u w=4u l=1u
X9 VSS.t20 BIAS.t3 BIAS.t4 VSS.t19 nfet_06v0 ad=8.8p pd=40.88u as=8.8p ps=40.88u w=20u l=4u
X10 VSS.t31 F_NAND_N.t5 SAFE_OUT.t0 VSS.t30 nfet_06v0 ad=1.76p pd=8.88u as=1.76p ps=8.88u w=4u l=1u
X11 PWM_DRIVE.t3 a_128036_20068.t5 VBUF.t7 VBUF.t6 pfet_05v0 ad=0.3782p pd=1.84u as=0.4941p ps=2.03u w=1.22u l=0.5u
X12 VSS.t14 FAULT.t0 FAULT_HB.t0 VSS.t13 nfet_06v0 ad=0.88p pd=4.88u as=0.88p ps=4.88u w=2u l=1u
X13 GATE.t1 PWM_DRIVE.t6 BIAS.t0 VSS.t2 nfet_06v0 ad=0.88p pd=4.88u as=0.88p ps=4.88u w=2u l=1u
X14 VBUF.t1 PWM_DRIVE.t4 PWM_B.t0 VBUF.t0 pfet_06v0 ad=1.76p pd=8.88u as=1.76p ps=8.88u w=4u l=1u
X15 VSS.t18 FAULT.t5 I_FAULT_B.t1 VSS.t17 nfet_06v0 ad=0.88p pd=4.88u as=0.88p ps=4.88u w=2u l=1u
X16 VREF.t5 CTRL.t4 SENSE.t0 VREF.t4 pfet_06v0 ad=44p pd=0.20088m as=44p ps=0.20088m w=100u l=10u
X17 VSAFE.t5 FAULT.t4 I_FAULT_B.t0 VSAFE.t4 pfet_06v0 ad=1.76p pd=8.88u as=1.76p ps=8.88u w=4u l=1u
X18 R_TAIL.t1 VSET.t0 R_N1.t0 VREF.t7 pfet_06v0 ad=44p pd=0.20088m as=44p ps=0.20088m w=100u l=10u
X19 VSS.t22 N2.t2 CTRL.t2 VSS.t21 nfet_06v0 ad=8.8p pd=40.88u as=8.8p ps=40.88u w=20u l=1u
X20 REFOUT.t0 FAULT.t6 BIAS.t2 VSAFE.t8 pfet_06v0 ad=8.8p pd=40.88u as=8.8p ps=40.88u w=20u l=1u
X21 VREF.t11 PB.t0 PB.t1 VREF.t10 pfet_06v0 ad=8.8p pd=40.88u as=8.8p ps=40.88u w=20u l=4u
X22 F_STACK1.t1 RAW_PWM.t0 F_NAND_N.t2 VSS.t8 nfet_06v0 ad=2.64p pd=12.88u as=2.64p ps=12.88u w=6u l=1u
X23 VBUF.t3 SAFE_OUT.t3 a_128036_20068.t0 VBUF.t2 pfet_05v0 ad=0.4941p pd=2.03u as=0.5368p ps=3.32u w=1.22u l=0.5u
X24 VBUF.t5 a_128036_20068.t4 PWM_DRIVE.t2 VBUF.t4 pfet_05v0 ad=0.5368p pd=3.32u as=0.3782p ps=1.84u w=1.22u l=0.5u
X25 VSS.t10 GATE.t2 LED_K.t1 VSS.t9 nfet_06v0 ad=8.8p pd=40.88u as=8.8p ps=40.88u w=20u l=4u
X26 VSS.t1 PWM_B.t2 GATE.t0 VSS.t0 nfet_06v0 ad=0.88p pd=4.88u as=0.88p ps=4.88u w=2u l=1u
X27 VREF.t9 PB.t2 R_TAIL.t2 VREF.t8 pfet_06v0 ad=8.8p pd=40.88u as=8.8p ps=40.88u w=20u l=4u
X28 VREF.t1 CTRL.t3 REFOUT.t2 VREF.t0 pfet_06v0 ad=44p pd=0.20088m as=44p ps=0.20088m w=100u l=10u
X29 VSS.t16 FAULT.t2 F_FAULT_B.t1 VSS.t15 nfet_06v0 ad=0.88p pd=4.88u as=0.88p ps=4.88u w=2u l=1u
X30 PWM_DRIVE.t1 a_128036_20068.t3 VSS.t35 VSS.t34 nfet_05v0 ad=0.2132p pd=1.34u as=0.2911p ps=1.53u w=0.82u l=0.6u
X31 VREF.t3 CTRL.t0 CTRL.t1 VREF.t2 pfet_06v0 ad=44p pd=0.20088m as=44p ps=0.20088m w=100u l=10u
X32 VSAFE.t7 FAULT.t1 F_FAULT_B.t0 VSAFE.t6 pfet_06v0 ad=1.76p pd=8.88u as=1.76p ps=8.88u w=4u l=1u
X33 VSAFE.t1 PERMIT.t1 F_NAND_N.t0 VSAFE.t0 pfet_06v0 ad=1.76p pd=8.88u as=1.76p ps=8.88u w=4u l=1u
X34 F_STACK2.t0 PERMIT.t0 F_STACK1.t0 VSS.t7 nfet_06v0 ad=2.64p pd=12.88u as=2.64p ps=12.88u w=6u l=1u
X35 VSAFE.t12 F_NAND_N.t4 SAFE_OUT.t1 VSAFE.t11 pfet_06v0 ad=3.52p pd=16.88u as=3.52p ps=16.88u w=8u l=1u
X36 VSS.t27 R_N1.t3 N2.t0 VSS.t26 nfet_06v0 ad=22p pd=0.10088m as=22p ps=0.10088m w=50u l=10u
X37 LED_A.t1 FAULT_HB.t1 LED_K.t0 LED_A.t0 pfet_06v0 ad=0.88p pd=4.88u as=0.88p ps=4.88u w=2u l=1u
X38 VSS.t4 PWM_DRIVE.t5 PWM_B.t1 VSS.t3 nfet_06v0 ad=0.88p pd=4.88u as=0.88p ps=4.88u w=2u l=1u
R0 PWM_B.n1 PWM_B.t2 31.2725
R1 PWM_B.n0 PWM_B.t0 22.0215
R2 PWM_B.n0 PWM_B.t1 20.6105
R3 PWM_B.n1 PWM_B.n0 2.5865
R4 PWM_B PWM_B.n1 0.0605
R5 PWM_DRIVE.n3 PWM_DRIVE.t4 36.9975
R6 PWM_DRIVE.n4 PWM_DRIVE.t5 29.9225
R7 PWM_DRIVE.n5 PWM_DRIVE.t6 29.9225
R8 PWM_DRIVE.n3 PWM_DRIVE.n2 21.2428
R9 PWM_DRIVE.n2 PWM_DRIVE.n0 6.929
R10 PWM_DRIVE.n5 PWM_DRIVE.n4 5.4005
R11 PWM_DRIVE.n2 PWM_DRIVE.n1 2.81668
R12 PWM_DRIVE.n4 PWM_DRIVE.n3 2.7005
R13 PWM_DRIVE.n1 PWM_DRIVE.t3 2.06607
R14 PWM_DRIVE.n0 PWM_DRIVE.t1 1.99806
R15 PWM_DRIVE.n0 PWM_DRIVE.t0 1.99806
R16 PWM_DRIVE.n1 PWM_DRIVE.t2 1.4923
R17 PWM_DRIVE PWM_DRIVE.n5 0.0605
R18 FAULT_HB.n0 FAULT_HB.t1 37.4615
R19 FAULT_HB.n0 FAULT_HB.t0 23.9855
R20 FAULT_HB FAULT_HB.n0 0.0605
R21 SAFE_OUT.n1 SAFE_OUT.n0 51.2012
R22 SAFE_OUT.n2 SAFE_OUT.t0 18.7385
R23 SAFE_OUT.n1 SAFE_OUT.t1 18.0749
R24 SAFE_OUT.n0 SAFE_OUT.t3 17.119
R25 SAFE_OUT.n0 SAFE_OUT.t2 12.7147
R26 SAFE_OUT.n2 SAFE_OUT.n1 2.7005
R27 SAFE_OUT SAFE_OUT.n2 0.0605
R28 PERMIT.n0 PERMIT.t0 60.9475
R29 PERMIT.n0 PERMIT.t1 45.7725
R30 PERMIT PERMIT.n0 0.0605
R31 RAW_PWM.n0 RAW_PWM.t0 62.2975
R32 RAW_PWM.n0 RAW_PWM.t1 47.1225
R33 RAW_PWM RAW_PWM.n0 0.0605
R34 LED_K.n0 LED_K.t1 36.4484
R35 LED_K.n0 LED_K.t0 23.1265
R36 LED_K LED_K.n0 0.0605
R37 GATE.n1 GATE.t2 46.4645
R38 GATE.n0 GATE.t0 23.7575
R39 GATE.n0 GATE.t1 21.2855
R40 GATE.n1 GATE.n0 2.8145
R41 GATE GATE.n1 0.0605
R42 FAULT.n3 FAULT.t6 113.172
R43 FAULT.n0 FAULT.t0 63.6725
R44 FAULT.n4 FAULT.t4 46.4475
R45 FAULT.n0 FAULT.t1 46.4475
R46 FAULT.n1 FAULT.t2 39.3725
R47 FAULT.n2 FAULT.t3 39.3725
R48 FAULT.n5 FAULT.t5 39.3725
R49 FAULT.n4 FAULT.n3 5.4005
R50 FAULT.n2 FAULT.n1 2.7005
R51 FAULT.n1 FAULT.n0 2.7005
R52 FAULT.n5 FAULT.n4 2.7005
R53 FAULT.n3 FAULT.n2 2.7005
R54 FAULT FAULT.n5 0.0605
R55 BIAS.n0 BIAS.t3 47.1395
R56 BIAS.n2 BIAS.n1 34.8755
R57 BIAS.n1 BIAS.t4 29.9234
R58 BIAS.n4 BIAS.t5 29.9234
R59 BIAS.n3 BIAS.t2 29.9063
R60 BIAS.n0 BIAS.t0 27.2465
R61 BIAS.n2 BIAS.t1 21.9605
R62 BIAS.n3 BIAS.n2 2.7005
R63 BIAS.n4 BIAS.n3 2.4725
R64 BIAS.n1 BIAS.n0 0.3395
R65 BIAS BIAS.n4 0.0605
R66 REFOUT.n0 REFOUT.t0 33.5093
R67 REFOUT.n0 REFOUT.t1 30.5984
R68 REFOUT.n1 REFOUT.t2 30.4091
R69 REFOUT.n1 REFOUT.n0 9.3755
R70 REFOUT REFOUT.n1 0.0605
R71 CTRL.n0 CTRL.t3 61.4639
R72 CTRL.n1 CTRL.t0 58.1639
R73 CTRL.n0 CTRL.t4 58.1639
R74 CTRL.n3 CTRL.t2 32.6234
R75 CTRL.n2 CTRL.t1 32.4341
R76 CTRL.n1 CTRL.n0 3.3005
R77 CTRL.n3 CTRL.n2 2.0255
R78 CTRL.n2 CTRL.n1 0.7895
R79 CTRL CTRL.n3 0.0605
R80 N2.n0 N2.t2 113.886
R81 N2.n0 N2.t0 33.1587
R82 N2.n1 N2.t1 33.1091
R83 N2.n1 N2.n0 6.6005
R84 N2 N2.n1 0.0605
R85 SENSE.n0 SENSE.t1 60.1889
R86 SENSE.n0 SENSE.t0 49.5701
R87 SENSE SENSE.n0 0.0605
R88 VSET VSET.t0 60.9239
R89 PB.n0 PB.t2 53.8895
R90 PB.n0 PB.t0 51.1895
R91 PB.n1 PB.t1 33.9563
R92 PB.n1 PB.n0 0.3395
R93 PB PB.n1 0.0605
R94 VBUF.n2 VBUF.t4 676.269
R95 VBUF.t6 VBUF.t2 505.793
R96 VBUF.t4 VBUF.t6 432.433
R97 VBUF.n3 VBUF.t0 143.114
R98 VBUF VBUF.n2 31.496
R99 VBUF.n3 VBUF.t1 29.4465
R100 VBUF.n1 VBUF.t5 6.80877
R101 VBUF.n1 VBUF.n0 5.65222
R102 VBUF.n0 VBUF.t3 2.61116
R103 VBUF.n0 VBUF.t7 2.03739
R104 VBUF VBUF.n3 1.574
R105 VBUF.n2 VBUF.n1 0.089
R106 LED_A LED_A.t0 191.798
R107 LED_A LED_A.t1 30.226
R108 VSAFE.n5 VSAFE.t4 143.79
R109 VSAFE.n7 VSAFE.t6 143.15
R110 VSAFE.n9 VSAFE.t2 143.15
R111 VSAFE.n4 VSAFE.t0 143.15
R112 VSAFE.n2 VSAFE.t9 143.15
R113 VSAFE.n0 VSAFE.t11 100.368
R114 VSAFE.n6 VSAFE.t8 73.5661
R115 VSAFE.n0 VSAFE.t12 30.1889
R116 VSAFE.n10 VSAFE.t3 30.1215
R117 VSAFE.n5 VSAFE.t5 30.1215
R118 VSAFE.n3 VSAFE.t1 30.1215
R119 VSAFE.n8 VSAFE.t7 30.1215
R120 VSAFE.n1 VSAFE.t10 30.1215
R121 VSAFE.n1 VSAFE.n0 12.8615
R122 VSAFE.n7 VSAFE.n6 8.1005
R123 VSAFE.n6 VSAFE.n5 4.7615
R124 VSAFE.n9 VSAFE.n8 2.0615
R125 VSAFE.n3 VSAFE.n2 2.0615
R126 VSAFE VSAFE.n4 1.061
R127 VSAFE VSAFE.n10 1.001
R128 VSAFE.n8 VSAFE.n7 0.6395
R129 VSAFE.n2 VSAFE.n1 0.6395
R130 VSAFE.n4 VSAFE.n3 0.6395
R131 VSAFE.n10 VSAFE.n9 0.6395
R132 VREF.n5 VREF.t10 108.567
R133 VREF.n6 VREF.t8 107.553
R134 VREF.n8 VREF.t7 73.8405
R135 VREF.n9 VREF.t6 73.8405
R136 VREF.n4 VREF.t2 73.8405
R137 VREF.n2 VREF.t4 73.8405
R138 VREF.n0 VREF.t0 73.8405
R139 VREF.n0 VREF.t1 41.7731
R140 VREF.n7 VREF.t9 40.0313
R141 VREF.n5 VREF.t11 40.0313
R142 VREF.n1 VREF.t5 39.8591
R143 VREF.n3 VREF.t3 39.8591
R144 VREF VREF.n9 6.4025
R145 VREF VREF.n4 6.1985
R146 VREF.n9 VREF.n8 3.3005
R147 VREF.n4 VREF.n3 1.9145
R148 VREF.n2 VREF.n1 1.9145
R149 VREF.n6 VREF.n5 1.6865
R150 VREF.n1 VREF.n0 1.3865
R151 VREF.n3 VREF.n2 1.3865
R152 VREF.n8 VREF.n7 1.2365
R153 VREF.n7 VREF.n6 1.0145
R154 VSS.n70 VSS.n69 16200.5
R155 VSS.t5 VSS.n9 8771.37
R156 VSS.n31 VSS.n30 7452.55
R157 VSS.n37 VSS.n36 7451.68
R158 VSS.n73 VSS.n72 3726.34
R159 VSS.n72 VSS.n2 3725.61
R160 VSS.n46 VSS.n4 3725.61
R161 VSS.n46 VSS.n3 3725.61
R162 VSS.n60 VSS.n59 3584.43
R163 VSS.n45 VSS.t13 2205.21
R164 VSS.n72 VSS.n46 2113.88
R165 VSS.n64 VSS.n48 1613.96
R166 VSS.n71 VSS.n47 1462.53
R167 VSS.n11 VSS.t32 1095.27
R168 VSS.n46 VSS.n45 854.586
R169 VSS.t34 VSS.t5 844.742
R170 VSS.t28 VSS.n3 733.232
R171 VSS.n69 VSS.t11 733.232
R172 VSS.t11 VSS.n2 733.232
R173 VSS.t7 VSS.n4 733.232
R174 VSS.n31 VSS.t7 733.232
R175 VSS.n36 VSS.t28 733.232
R176 VSS.t32 VSS.t34 722.222
R177 VSS.n71 VSS.n70 638.297
R178 VSS.n40 VSS.t13 560.308
R179 VSS.n70 VSS.n48 484.923
R180 VSS.n52 VSS.n51 460.865
R181 VSS.n60 VSS.n48 446.022
R182 VSS.n37 VSS.t30 367.012
R183 VSS.n73 VSS.t15 366.914
R184 VSS.n30 VSS.t8 366.125
R185 VSS.n62 VSS.n61 337.632
R186 VSS.n58 VSS.n50 324.086
R187 VSS.n72 VSS.n71 292.26
R188 VSS.n17 VSS.n16 244.059
R189 VSS.n18 VSS.n7 244.059
R190 VSS.n24 VSS.n23 219.718
R191 VSS.n45 VSS.n44 214.201
R192 VSS.n25 VSS.n5 195.376
R193 VSS.n51 VSS.t26 189.5
R194 VSS.n59 VSS.n58 126.121
R195 VSS.n50 VSS.t23 91.8086
R196 VSS.t25 VSS.n47 76.8867
R197 VSS.n64 VSS.t25 76.8867
R198 VSS.n59 VSS.t26 63.378
R199 VSS.n61 VSS.t17 61.8791
R200 VSS.n61 VSS.n60 51.5479
R201 VSS.n44 VSS.t19 48.3578
R202 VSS.n25 VSS.t9 48.3578
R203 VSS.t9 VSS.n24 48.3578
R204 VSS.n5 VSS.t19 48.3578
R205 VSS.n55 VSS.n50 47.9593
R206 VSS.n53 VSS.n52 42.0944
R207 VSS.n66 VSS.n65 41.9739
R208 VSS.n43 VSS.n42 41.8839
R209 VSS.n27 VSS.n26 41.8839
R210 VSS.n57 VSS.n56 41.8825
R211 VSS.n28 VSS.t20 41.8484
R212 VSS.n49 VSS.t22 41.8484
R213 VSS.n6 VSS.t10 41.8484
R214 VSS.n54 VSS.t27 41.7087
R215 VSS.n55 VSS.t24 41.7087
R216 VSS.n1 VSS.t12 33.8855
R217 VSS.n8 VSS.t1 33.8855
R218 VSS.n41 VSS.t14 33.8855
R219 VSS.n13 VSS.t4 33.8855
R220 VSS.n63 VSS.t18 33.8855
R221 VSS.n75 VSS.t16 33.8855
R222 VSS.n30 VSS.n0 33.1827
R223 VSS.n39 VSS.t31 32.6885
R224 VSS.n74 VSS.n73 32.5978
R225 VSS.n38 VSS.n37 32.3251
R226 VSS.n29 VSS.t29 32.2491
R227 VSS.n13 VSS.n12 32.1276
R228 VSS.n15 VSS.n14 31.8691
R229 VSS.n20 VSS.n19 31.8691
R230 VSS.n22 VSS.n21 31.8691
R231 VSS.n68 VSS.n67 31.8691
R232 VSS.n33 VSS.n32 31.8545
R233 VSS.n35 VSS.n34 31.8545
R234 VSS.n52 VSS.t21 24.5572
R235 VSS.t0 VSS.n17 24.0169
R236 VSS.n18 VSS.t0 24.0169
R237 VSS.n7 VSS.t2 24.0169
R238 VSS.n23 VSS.t2 24.0169
R239 VSS.n9 VSS.t3 24.0169
R240 VSS.n16 VSS.t3 24.0169
R241 VSS.n57 VSS.n51 12.246
R242 VSS.n11 VSS.t33 8.37615
R243 VSS.n12 VSS.n10 6.37859
R244 VSS.n26 VSS.n24 5.47319
R245 VSS.n43 VSS.n5 5.47319
R246 VSS.n65 VSS.n47 4.89781
R247 VSS.n10 VSS.t6 2.72794
R248 VSS.n10 VSS.t35 2.72794
R249 VSS.n36 VSS.n35 2.65957
R250 VSS.n32 VSS.n4 2.65957
R251 VSS.n15 VSS.n9 2.64852
R252 VSS.n68 VSS.n2 2.64852
R253 VSS.n22 VSS.n7 2.64852
R254 VSS.n19 VSS.n17 2.64852
R255 VSS.n69 VSS.n68 1.45586
R256 VSS.n19 VSS.n18 1.45586
R257 VSS.n23 VSS.n22 1.45586
R258 VSS.n16 VSS.n15 1.45586
R259 VSS.n62 VSS.n49 0.897575
R260 VSS.n35 VSS.n3 0.685319
R261 VSS.n32 VSS.n31 0.685319
R262 VSS VSS.n75 0.56795
R263 VSS.n67 VSS.n66 0.4055
R264 VSS VSS.n0 0.397625
R265 VSS.n66 VSS.n63 0.357575
R266 VSS.n40 VSS.n39 0.357575
R267 VSS.n12 VSS.n11 0.35075
R268 VSS.n42 VSS.n41 0.346325
R269 VSS.n44 VSS.n43 0.229745
R270 VSS.n26 VSS.n25 0.229745
R271 VSS.n65 VSS.n64 0.229735
R272 VSS.n21 VSS.n20 0.203
R273 VSS.n33 VSS.n0 0.203
R274 VSS.n34 VSS.n33 0.203
R275 VSS.n38 VSS.n29 0.155075
R276 VSS.n14 VSS.n8 0.155075
R277 VSS.n74 VSS.n1 0.155075
R278 VSS.n54 VSS.n53 0.14945
R279 VSS.n56 VSS.n54 0.14405
R280 VSS.n21 VSS.n6 0.1382
R281 VSS.n28 VSS.n27 0.12695
R282 VSS.n56 VSS.n55 0.10445
R283 VSS.n58 VSS.n57 0.0954664
R284 VSS.n42 VSS.n28 0.07655
R285 VSS.n27 VSS.n6 0.07655
R286 VSS.n67 VSS.n1 0.048425
R287 VSS.n63 VSS.n62 0.048425
R288 VSS.n14 VSS.n13 0.048425
R289 VSS.n53 VSS.n49 0.048425
R290 VSS.n34 VSS.n29 0.048425
R291 VSS.n20 VSS.n8 0.048425
R292 VSS.n39 VSS.n38 0.048425
R293 VSS.n41 VSS.n40 0.048425
R294 VSS.n75 VSS.n74 0.048425
R295 a_128036_20068.n1 a_128036_20068.t5 17.8125
R296 a_128036_20068.n0 a_128036_20068.t4 17.8125
R297 a_128036_20068.n1 a_128036_20068.t3 11.8022
R298 a_128036_20068.n0 a_128036_20068.t2 11.8022
R299 a_128036_20068.n2 a_128036_20068.n0 9.53106
R300 a_128036_20068.n3 a_128036_20068.t1 8.88697
R301 a_128036_20068.t0 a_128036_20068.n3 4.21752
R302 a_128036_20068.n3 a_128036_20068.n2 3.64621
R303 a_128036_20068.n2 a_128036_20068.n1 1.01439
R304 F_STACK2.n0 F_STACK2.t1 15.3711
R305 F_STACK2.n0 F_STACK2.t0 12.8991
R306 F_STACK2 F_STACK2.n0 0.0305
R307 F_STACK1.n0 F_STACK1.t0 16.0461
R308 F_STACK1.n0 F_STACK1.t1 13.5741
R309 F_STACK1 F_STACK1.n0 0.0305
R310 F_NAND_N.n0 F_NAND_N.t4 50.4725
R311 F_NAND_N.n0 F_NAND_N.t5 33.6225
R312 F_NAND_N.n4 F_NAND_N.t1 14.5965
R313 F_NAND_N.n3 F_NAND_N.t0 14.5965
R314 F_NAND_N.n2 F_NAND_N.t3 14.5965
R315 F_NAND_N.n1 F_NAND_N.t2 14.2491
R316 F_NAND_N.n1 F_NAND_N.n0 8.2145
R317 F_NAND_N.n2 F_NAND_N.n1 2.7005
R318 F_NAND_N.n3 F_NAND_N.n2 2.7005
R319 F_NAND_N.n4 F_NAND_N.n3 2.7005
R320 F_NAND_N F_NAND_N.n4 0.0305
R321 F_FAULT_B.n0 F_FAULT_B.t2 49.4725
R322 F_FAULT_B.n0 F_FAULT_B.t3 34.2975
R323 F_FAULT_B.n2 F_FAULT_B.t1 16.5605
R324 F_FAULT_B.n1 F_FAULT_B.t0 15.2715
R325 F_FAULT_B.n1 F_FAULT_B.n0 8.2145
R326 F_FAULT_B.n2 F_FAULT_B.n1 2.7005
R327 F_FAULT_B F_FAULT_B.n2 0.0305
R328 I_FAULT_B.n0 I_FAULT_B.t2 104.511
R329 I_FAULT_B.n1 I_FAULT_B.t1 17.2355
R330 I_FAULT_B.n0 I_FAULT_B.t0 15.9465
R331 I_FAULT_B.n1 I_FAULT_B.n0 2.7005
R332 I_FAULT_B I_FAULT_B.n1 0.0305
R333 R_N1.n0 R_N1.t3 42.0889
R334 R_N1.n0 R_N1.t1 38.7889
R335 R_N1.n1 R_N1.t2 25.7337
R336 R_N1.n2 R_N1.t0 25.6841
R337 R_N1.n2 R_N1.n1 6.6005
R338 R_N1.n1 R_N1.n0 0.7895
R339 R_N1 R_N1.n2 0.0305
R340 R_TAIL.n0 R_TAIL.t0 29.6591
R341 R_TAIL.n1 R_TAIL.t2 26.5313
R342 R_TAIL.n0 R_TAIL.t1 26.3591
R343 R_TAIL.n1 R_TAIL.n0 3.8285
R344 R_TAIL R_TAIL.n1 0.0305
C0 SAFE_OUT FAULT_HB 0.13546f
C1 FAULT RAW_PWM 0.82564f
C2 BIAS PERMIT 0.16409f
C3 GATE LED_K 1.83946f
C4 VSAFE SAFE_OUT 1.80603f
C5 CTRL REFOUT 5.61736f
C6 F_FAULT_B PERMIT 0.15825f
C7 F_NAND_N RAW_PWM 1.77935f
C8 VREF REFOUT 10.8486f
C9 F_STACK1 F_STACK2 0.18601f
C10 BIAS RAW_PWM 0.16409f
C11 VSAFE PERMIT 4.03524f
C12 VREF CTRL 39.6577f
C13 F_FAULT_B RAW_PWM 0.15825f
C14 F_NAND_N F_STACK2 0.105f
C15 R_N1 VREF 10.6073f
C16 GATE PWM_B 1.62358f
C17 BIAS LED_K 0.371f
C18 LED_A LED_K 0.8968f
C19 VSAFE RAW_PWM 4.48149f
C20 N2 CTRL 4.21816f
C21 VREF N2 10.892f
C22 R_N1 N2 3.06997f
C23 R_TAIL VREF 22.5779f
C24 F_FAULT_B F_STACK2 0.61279f
C25 F_NAND_N F_STACK1 0.40026f
C26 R_TAIL R_N1 0.58496f
C27 GATE PWM_DRIVE 1.52264f
C28 LED_K FAULT_HB 2.14825f
C29 BIAS GATE 0.52029f
C30 VBUF PWM_B 1.11538f
C31 SENSE CTRL 5.65498f
C32 VREF SENSE 15.119f
C33 R_TAIL N2 0.08332f
C34 R_N1 SENSE 0.08694f
C35 F_FAULT_B F_STACK1 0
C36 PWM_DRIVE PWM_B 2.96956f
C37 RAW_PWM PERMIT 0.08673f
C38 LED_K SAFE_OUT 0.15616f
C39 BIAS FAULT 5.84887f
C40 VBUF PWM_DRIVE 3.4753f
C41 SENSE N2 6.07416f
C42 VREF VSET 4.00679f
C43 F_FAULT_B FAULT 1.97441f
C44 R_TAIL SENSE 5.53213f
C45 R_N1 VSET 5.51841f
C46 F_FAULT_B F_NAND_N 2.06857f
C47 GATE SAFE_OUT 0.44832f
C48 BIAS PWM_DRIVE 1.3908f
C49 FAULT FAULT_HB 2.24459f
C50 REFOUT FAULT 4.0131f
C51 F_STACK2 PERMIT 0.61309f
C52 LED_A BIAS 0.16459f
C53 VSAFE FAULT 9.62514f
C54 VREF PB 11.1112f
C55 I_FAULT_B FAULT 2.20426f
C56 R_TAIL VSET 5.53297f
C57 F_NAND_N VSAFE 4.05926f
C58 SAFE_OUT PWM_B 0.64779f
C59 FAULT SAFE_OUT 0.06198f
C60 BIAS FAULT_HB 0.13484f
C61 REFOUT BIAS 1.85406f
C62 VBUF SAFE_OUT 0.3592f
C63 LED_A FAULT_HB 2.82538f
C64 F_NAND_N SAFE_OUT 1.80549f
C65 VSAFE BIAS 3.44388f
C66 F_STACK1 PERMIT 0.72772f
C67 I_FAULT_B BIAS 2.88547f
C68 R_TAIL PB 1.78642f
C69 F_FAULT_B VSAFE 2.88534f
C70 SAFE_OUT PWM_DRIVE 1.45109f
C71 FAULT PERMIT 0.67144f
C72 BIAS SAFE_OUT 0.24556f
C73 LED_A SAFE_OUT 0.16522f
C74 F_STACK1 RAW_PWM 0.72802f
C75 F_NAND_N PERMIT 0.96271f
C76 VSAFE REFOUT 1.90305f
C77 I_FAULT_B REFOUT 2.94628f
C78 I_FAULT_B VSAFE 0.95086f
C79 PWM_B VSS 6.99539f
C80 PWM_DRIVE VSS 8.45111f
C81 FAULT_HB VSS 4.03392f
C82 SAFE_OUT VSS 15.25524f
C83 PERMIT VSS 8.4792f
C84 RAW_PWM VSS 8.76536f
C85 LED_K VSS 8.32757f
C86 GATE VSS 11.14622f
C87 FAULT VSS 42.49282f
C88 BIAS VSS 40.60715f
C89 REFOUT VSS 16.1362f
C90 CTRL VSS 21.14f
C91 N2 VSS 21.78966f
C92 SENSE VSS 13.70772f
C93 VSET VSS 6.80032f
C94 PB VSS 10.3187f
C95 VBUF VSS 22.77271f
C96 LED_A VSS 14.2036f
C97 VSAFE VSS 0.11149p
C98 VREF VSS 0.9383p
C99 F_STACK2 VSS 3.09887f
C100 F_STACK1 VSS 3.0069f
C101 F_NAND_N VSS 10.13802f
C102 F_FAULT_B VSS 10.28664f
C103 I_FAULT_B VSS 5.41583f
C104 R_N1 VSS 30.25485f
C105 R_TAIL VSS 12.23386f
C106 R_TAIL.t0 VSS 22.9232f
C107 R_TAIL.t1 VSS 17.29675f
C108 R_TAIL.n0 VSS 6.65754f
C109 R_TAIL.t2 VSS 5.70492f
C110 R_TAIL.n1 VSS 3.12717f
C111 R_N1.n0 VSS 2.53489f
C112 R_N1.t2 VSS 4.32782f
C113 R_N1.n1 VSS 0.46567f
C114 R_N1.t0 VSS 7.53848f
C115 R_N1.n2 VSS 0.44148f
C116 I_FAULT_B.t0 VSS 1.15244f
C117 I_FAULT_B.n0 VSS 4.5614f
C118 I_FAULT_B.t1 VSS 0.99032f
C119 I_FAULT_B.n1 VSS 1.10651f
C120 F_FAULT_B.n0 VSS 3.69228f
C121 F_FAULT_B.t0 VSS 0.8503f
C122 F_FAULT_B.n1 VSS 1.63519f
C123 F_FAULT_B.t1 VSS 0.74943f
C124 F_FAULT_B.n2 VSS 0.6648f
C125 F_NAND_N.n0 VSS 3.03748f
C126 F_NAND_N.t2 VSS 1.32574f
C127 F_NAND_N.n1 VSS 1.93999f
C128 F_NAND_N.t3 VSS 0.67803f
C129 F_NAND_N.n2 VSS 1.13281f
C130 F_NAND_N.t0 VSS 0.94491f
C131 F_NAND_N.n3 VSS 1.13281f
C132 F_NAND_N.t1 VSS 1.0056f
C133 F_NAND_N.n4 VSS 0.7385f
C134 F_STACK1.t0 VSS 1.20766f
C135 F_STACK1.t1 VSS 1.19417f
C136 F_STACK1.n0 VSS 1.02199f
C137 F_STACK2.t1 VSS 0.75754f
C138 F_STACK2.t0 VSS 1.00085f
C139 F_STACK2.n0 VSS 0.75918f
C140 a_128036_20068.t1 VSS 0.07661f
C141 a_128036_20068.n0 VSS 0.13559f
C142 a_128036_20068.n1 VSS 0.12119f
C143 a_128036_20068.n2 VSS 0.05183f
C144 a_128036_20068.n3 VSS 0.30493f
C145 a_128036_20068.t0 VSS 0.0936f
C146 VSS.t12 VSS 0.41904f
C147 VSS.t10 VSS 1.43518f
C148 VSS.t1 VSS 0.3122f
C149 VSS.t35 VSS 0.06374f
C150 VSS.t6 VSS 0.01564f
C151 VSS.t33 VSS 0.06374f
C152 VSS.t4 VSS 0.32306f
C153 VSS.t20 VSS 1.49915f
C154 VSS.t29 VSS 0.35092f
C155 VSS.t31 VSS 0.22423f
C156 VSS.t14 VSS 1.25495f
C157 VSS.t22 VSS 1.03482f
C158 VSS.t27 VSS 3.62108f
C159 VSS.t24 VSS 3.56977f
C160 VSS.t18 VSS 0.41904f
C161 VSS.t16 VSS 0.41904f
C162 VREF.t1 VSS 8.62506f
C163 VREF.t0 VSS 16.4322f
C164 VREF.n0 VSS 5.85499f
C165 VREF.t5 VSS 8.52061f
C166 VREF.n1 VSS 0.49994f
C167 VREF.t4 VSS 16.4322f
C168 VREF.n2 VSS 5.41246f
C169 VREF.t3 VSS 8.52061f
C170 VREF.n3 VSS 0.49994f
C171 VREF.t2 VSS 16.4322f
C172 VREF.n4 VSS 5.55326f
C173 VREF.t10 VSS 1.80488f
C174 VREF.t11 VSS 2.396f
C175 VREF.n5 VSS 2.20367f
C176 VREF.t8 VSS 1.78867f
C177 VREF.n6 VSS 1.7807f
C178 VREF.t9 VSS 2.43784f
C179 VREF.n7 VSS 0.47096f
C180 VREF.t7 VSS 16.4322f
C181 VREF.n8 VSS 5.44863f
C182 VREF.t6 VSS 16.4322f
C183 VREF.n9 VSS 5.59978f
C184 VSAFE.t12 VSS 1.13056f
C185 VSAFE.t11 VSS 1.0897f
C186 VSAFE.n0 VSS 3.49485f
C187 VSAFE.t10 VSS 0.86511f
C188 VSAFE.n1 VSS 1.52646f
C189 VSAFE.t9 VSS 0.62781f
C190 VSAFE.n2 VSS 1.93846f
C191 VSAFE.t1 VSS 1.132f
C192 VSAFE.n3 VSS 0.80376f
C193 VSAFE.t0 VSS 0.62781f
C194 VSAFE.n4 VSS 1.87151f
C195 VSAFE.t4 VSS 0.63585f
C196 VSAFE.t5 VSS 1.08961f
C197 VSAFE.n5 VSS 2.78698f
C198 VSAFE.t8 VSS 3.06265f
C199 VSAFE.n6 VSS 3.3661f
C200 VSAFE.t6 VSS 0.62781f
C201 VSAFE.n7 VSS 2.34257f
C202 VSAFE.t7 VSS 1.08961f
C203 VSAFE.n8 VSS 0.80376f
C204 VSAFE.t2 VSS 0.62781f
C205 VSAFE.n9 VSS 1.93846f
C206 VSAFE.t3 VSS 1.19269f
C207 VSAFE.n10 VSS 0.7328f
C208 LED_A.t1 VSS 1.41958f
C209 LED_A.t0 VSS 0.50406f
C210 VBUF.t2 VSS 0.14913f
C211 VBUF.t6 VSS 0.09268f
C212 VBUF.t4 VSS 0.1101f
C213 VBUF.t5 VSS 0.08223f
C214 VBUF.t7 VSS 0.07517f
C215 VBUF.t3 VSS 0.02419f
C216 VBUF.n0 VSS 0.01782f
C217 VBUF.n1 VSS 0.08387f
C218 VBUF.n2 VSS 0.78507f
C219 VBUF.t0 VSS 0.5513f
C220 VBUF.t1 VSS 0.9324f
C221 VBUF.n3 VSS 2.22084f
C222 PB.n0 VSS 3.27167f
C223 PB.t1 VSS 3.21944f
C224 PB.n1 VSS 0.92417f
C225 SENSE.t0 VSS 9.97577f
C226 SENSE.n0 VSS 6.52557f
C227 N2.t0 VSS 8.2337f
C228 N2.n0 VSS 7.30044f
C229 N2.t1 VSS 18.96752f
C230 N2.n1 VSS 2.92081f
C231 CTRL.n0 VSS 6.13861f
C232 CTRL.n1 VSS 3.12133f
C233 CTRL.t1 VSS 8.60294f
C234 CTRL.n2 VSS 0.44335f
C235 CTRL.t2 VSS 1.60674f
C236 CTRL.n3 VSS 0.42111f
C237 REFOUT.t0 VSS 4.42058f
C238 REFOUT.t1 VSS 4.4099f
C239 REFOUT.n0 VSS 7.04859f
C240 REFOUT.t2 VSS 16.27423f
C241 REFOUT.n1 VSS 3.99535f
C242 BIAS.t0 VSS 0.81281f
C243 BIAS.n0 VSS 2.1141f
C244 BIAS.t4 VSS 2.60779f
C245 BIAS.n1 VSS 3.0952f
C246 BIAS.t1 VSS 0.76386f
C247 BIAS.n2 VSS 2.97913f
C248 BIAS.t2 VSS 1.88005f
C249 BIAS.n3 VSS 1.00831f
C250 BIAS.t5 VSS 2.10364f
C251 BIAS.n4 VSS 0.82535f
C252 FAULT.n0 VSS 7.51358f
C253 FAULT.n1 VSS 1.98481f
C254 FAULT.n2 VSS 1.98481f
C255 FAULT.n3 VSS 3.65779f
C256 FAULT.n4 VSS 2.42789f
C257 FAULT.n5 VSS 1.6528f
C258 GATE.t0 VSS 0.67861f
C259 GATE.t1 VSS 0.63636f
C260 GATE.n0 VSS 1.14604f
C261 GATE.n1 VSS 1.25216f
C262 LED_K.t1 VSS 3.51887f
C263 LED_K.t0 VSS 1.32505f
C264 LED_K.n0 VSS 2.69776f
C265 RAW_PWM.n0 VSS 5.6992f
C266 PERMIT.n0 VSS 5.16313f
C267 SAFE_OUT.n0 VSS 1.67589f
C268 SAFE_OUT.t1 VSS 0.92995f
C269 SAFE_OUT.n1 VSS 4.30059f
C270 SAFE_OUT.t0 VSS 0.67712f
C271 SAFE_OUT.n2 VSS 0.6251f
C272 FAULT_HB.t0 VSS 2.66802f
C273 FAULT_HB.n0 VSS 4.64394f
C274 PWM_DRIVE.t0 VSS 0.07368f
C275 PWM_DRIVE.t1 VSS 0.07368f
C276 PWM_DRIVE.n0 VSS 0.02279f
C277 PWM_DRIVE.t2 VSS 0.08358f
C278 PWM_DRIVE.t3 VSS 0.08926f
C279 PWM_DRIVE.n1 VSS 0.0372f
C280 PWM_DRIVE.n2 VSS 1.09692f
C281 PWM_DRIVE.n3 VSS 3.4486f
C282 PWM_DRIVE.n4 VSS 2.47553f
C283 PWM_DRIVE.n5 VSS 1.9834f
C284 PWM_B.t0 VSS 1.35625f
C285 PWM_B.t1 VSS 1.02968f
C286 PWM_B.n0 VSS 2.62996f
C287 PWM_B.n1 VSS 1.38292f
.ends
