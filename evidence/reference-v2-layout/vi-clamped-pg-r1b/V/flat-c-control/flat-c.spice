* NGSPICE file created from nrz_vi_reference.ext - technology: gf180mcuD

X0 VSS IN1 IN2 VSS nfet_06v0 ad=22p pd=0.10088m as=22p ps=0.10088m w=50u l=10u
X1 VSS IN1 IN1 VSS nfet_06v0 ad=22p pd=0.10088m as=22p ps=0.10088m w=50u l=10u
X2 VIN ICTRL IOUT VIN pfet_06v0 ad=44p pd=0.20088m as=44p ps=0.20088m w=100u l=10u
X3 VIN ICTRL ICTRL VIN pfet_06v0 ad=44p pd=0.20088m as=44p ps=0.20088m w=100u l=10u
X4 VSS DISABLE IOUT VSS nfet_06v0 ad=4.4p pd=20.88u as=4.4p ps=20.88u w=10u l=0.7u
X5 ITAIL SENSE IN2 VIN pfet_06v0 ad=44p pd=0.20088m as=44p ps=0.20088m w=100u l=10u
X6 VSS IN2 ICTRL VSS nfet_06v0 ad=8.8p pd=40.88u as=8.8p ps=40.88u w=20u l=1u
X7 VIN IPB IPB VIN pfet_06v0 ad=8.8p pd=40.88u as=8.8p ps=40.88u w=20u l=4u
X8 VIN ICTRL SENSE VIN pfet_06v0 ad=44p pd=0.20088m as=44p ps=0.20088m w=100u l=10u
X9 ITAIL VSET IN1 VIN pfet_06v0 ad=44p pd=0.20088m as=44p ps=0.20088m w=100u l=10u
X10 VIN IPB ITAIL VIN pfet_06v0 ad=8.8p pd=40.88u as=8.8p ps=40.88u w=20u l=4u
C0 VIN IOUT 14.2834f
C1 ITAIL IPB 1.37509f
C2 IN1 VIN 12.5388f
C3 IOUT DISABLE 1.26984f
C4 VIN ICTRL 42.5313f
C5 ITAIL VIN 23.4452f
C6 VIN IN2 12.0698f
C7 ICTRL IOUT 7.17502f
C8 VIN SENSE 16.1167f
C9 ITAIL IN1 0.69787f
C10 VIN VSET 4.33794f
C11 IN1 IN2 3.12801f
C12 IN2 ICTRL 1.15305f
C13 ITAIL IN2 0.12982f
C14 IN1 SENSE 0.06934f
C15 VIN IPB 12.2117f
C16 SENSE ICTRL 5.76417f
C17 ITAIL SENSE 5.60795f
C18 IN1 VSET 5.6066f
C19 SENSE IN2 6.00575f
C20 ITAIL VSET 5.60893f
C21 DISABLE VSS 7.27983f
C22 IOUT VSS 22.3066f
C23 ICTRL VSS 41.8608f
C24 IN2 VSS 26.967f
C25 SENSE VSS 19.6637f
C26 VSET VSS 9.3813f
C27 IPB VSS 15.7534f
C28 VIN VSS 0.96886p
C29 IN1 VSS 44.9442f ; **FLOATING
C30 ITAIL VSS 21.2564f ; **FLOATING
