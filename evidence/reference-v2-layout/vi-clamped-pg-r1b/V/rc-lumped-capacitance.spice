* C-placement sensitivity control: same full R/MOS, all .ext C at original nets.
.subckt nrz_vi_reference VIN VSS VSET SENSE IOUT IPB IN2 ICTRL DISABLE
X0 VSS.t7 IN1.t3 IN2.t0 VSS.t6 nfet_06v0 ad=22p pd=0.10088m as=22p ps=0.10088m w=50u l=10u
X1 VSS.t5 IN1.t1 IN1.t2 VSS.t4 nfet_06v0 ad=22p pd=0.10088m as=22p ps=0.10088m w=50u l=10u
X2 VIN.t1 ICTRL.t3 IOUT.t1 VIN.t0 pfet_06v0 ad=44p pd=0.20088m as=44p ps=0.20088m w=100u l=10u
X3 VIN.t3 ICTRL.t0 ICTRL.t1 VIN.t2 pfet_06v0 ad=44p pd=0.20088m as=44p ps=0.20088m w=100u l=10u
X4 VSS.t1 DISABLE.t0 IOUT.t0 VSS.t0 nfet_06v0 ad=4.4p pd=20.88u as=4.4p ps=20.88u w=10u l=0.7u
X5 ITAIL.t0 SENSE.t1 IN2.t1 VIN.t6 pfet_06v0 ad=44p pd=0.20088m as=44p ps=0.20088m w=100u l=10u
X6 VSS.t3 IN2.t2 ICTRL.t2 VSS.t2 nfet_06v0 ad=8.8p pd=40.88u as=8.8p ps=40.88u w=20u l=1u
X7 VIN.t11 IPB.t0 IPB.t1 VIN.t10 pfet_06v0 ad=8.8p pd=40.88u as=8.8p ps=40.88u w=20u l=4u
X8 VIN.t5 ICTRL.t4 SENSE.t0 VIN.t4 pfet_06v0 ad=44p pd=0.20088m as=44p ps=0.20088m w=100u l=10u
X9 ITAIL.t1 VSET.t0 IN1.t0 VIN.t7 pfet_06v0 ad=44p pd=0.20088m as=44p ps=0.20088m w=100u l=10u
X10 VIN.t9 IPB.t2 ITAIL.t2 VIN.t8 pfet_06v0 ad=8.8p pd=40.88u as=8.8p ps=40.88u w=20u l=4u
R0 DISABLE DISABLE.t0 105.593
R1 IOUT.n11 IOUT.n10 27.0723
R2 IOUT.n20 IOUT.n19 21.1463
R3 IOUT.n15 IOUT.t1 7.79795
R4 IOUT.n4 IOUT.t0 4.70498
R5 IOUT.n6 IOUT.n5 4.57095
R6 IOUT.n16 IOUT.n15 4.57095
R7 IOUT.n10 IOUT.n9 4.5005
R8 IOUT.n18 IOUT.n17 4.5005
R9 IOUT.n19 IOUT.n18 4.5005
R10 IOUT.n14 IOUT.n13 4.5005
R11 IOUT.n5 IOUT.n4 4.5005
R12 IOUT.n2 IOUT.n1 4.5005
R13 IOUT.n8 IOUT.n7 4.5005
R14 IOUT.n9 IOUT.n8 4.5005
R15 IOUT.n3 IOUT.n2 4.5005
R16 IOUT.n22 IOUT.n11 4.5005
R17 IOUT.n22 IOUT.n0 3.95876
R18 IOUT.n22 IOUT.n21 2.27432
R19 IOUT.n7 IOUT.n6 2.21603
R20 IOUT.n17 IOUT.n16 2.21603
R21 IOUT.n7 IOUT.n0 0.975654
R22 IOUT.n5 IOUT.n2 0.142605
R23 IOUT.n9 IOUT.n2 0.142605
R24 IOUT.n18 IOUT.n14 0.142605
R25 IOUT.n8 IOUT.n3 0.142605
R26 IOUT.n21 IOUT.n20 0.079578
R27 IOUT.n6 IOUT.n3 0.0709482
R28 IOUT.n16 IOUT.n14 0.0709482
R29 IOUT.n20 IOUT.n11 0.068
R30 IOUT.n19 IOUT.n13 0.0545
R31 IOUT.n15 IOUT.n13 0.0545
R32 IOUT.n10 IOUT.n1 0.0458782
R33 IOUT.n4 IOUT.n1 0.0458782
R34 IOUT.n21 IOUT.n12 0.0123666
R35 IOUT.n17 IOUT.n0 0.00877641
R36 IOUT IOUT.n22 0.006125
R37 ICTRL.n0 ICTRL.t3 104.13
R38 ICTRL.n0 ICTRL.t4 99.1807
R39 ICTRL.n1 ICTRL.t0 99.1807
R40 ICTRL.n2 ICTRL.t1 41.0168
R41 ICTRL.n3 ICTRL.t2 31.7324
R42 ICTRL.n1 ICTRL.n0 4.9505
R43 ICTRL.n3 ICTRL.n2 3.038
R44 ICTRL.n2 ICTRL.n1 1.184
R45 ICTRL ICTRL.n3 0.0905
R46 IN2.n0 IN2.t2 130.244
R47 IN2.n1 IN2.t1 41.4905
R48 IN2.n0 IN2.t0 35.619
R49 IN2.n1 IN2.n0 9.9005
R50 IN2 IN2.n1 0.0905
R51 SENSE.n0 SENSE.t1 101.076
R52 SENSE.n0 SENSE.t0 65.578
R53 SENSE SENSE.n0 0.0905
R54 VSET VSET.t0 101.639
R55 IPB.n0 IPB.t2 68.1472
R56 IPB.n0 IPB.t0 64.0972
R57 IPB.n1 IPB.t1 32.6627
R58 IPB.n1 IPB.n0 0.509
R59 IPB IPB.n1 0.0905
R60 VIN.n107 VIN.t8 102.373
R61 VIN.n125 VIN.t10 102.373
R62 VIN.n74 VIN.t2 64.616
R63 VIN.n41 VIN.t0 64.616
R64 VIN.n57 VIN.t4 64.616
R65 VIN.n90 VIN.t7 64.616
R66 VIN.n80 VIN.t6 64.616
R67 VIN.n33 VIN.n23 21.1752
R68 VIN.n87 VIN.n12 18.9005
R69 VIN.n120 VIN.n119 18.3042
R70 VIN.n109 VIN.n1 18.3042
R71 VIN.n54 VIN.n53 18.3042
R72 VIN.n130 VIN.n129 18.3042
R73 VIN.n97 VIN.n96 18.3042
R74 VIN.n43 VIN.n23 18.3042
R75 VIN.n99 VIN.n98 18.3042
R76 VIN.n76 VIN.n12 18.3042
R77 VIN.n66 VIN.n65 18.3042
R78 VIN.n64 VIN.n63 18.3042
R79 VIN.n87 VIN.n86 18.3042
R80 VIN.n21 VIN.t3 9.59795
R81 VIN.n47 VIN.t5 9.59795
R82 VIN.n31 VIN.t1 9.59795
R83 VIN.n113 VIN.t11 6.17014
R84 VIN.n10 VIN.t9 6.17014
R85 VIN.n97 VIN.n87 4.9505
R86 VIN.n115 VIN.n114 4.57095
R87 VIN.n40 VIN.n37 4.57095
R88 VIN.n126 VIN.n125 4.57095
R89 VIN.n9 VIN.n6 4.57095
R90 VIN.n49 VIN.n48 4.57095
R91 VIN.n73 VIN.n70 4.57095
R92 VIN.n92 VIN.n91 4.57095
R93 VIN.n20 VIN.n17 4.57095
R94 VIN.n82 VIN.n81 4.57095
R95 VIN.n59 VIN.n58 4.57095
R96 VIN.n30 VIN.n27 4.57095
R97 VIN.n106 VIN.n103 4.57095
R98 VIN.n107 VIN.n106 4.5005
R99 VIN.n108 VIN.n105 4.5005
R100 VIN.n45 VIN.n44 4.5005
R101 VIN.n39 VIN.n38 4.5005
R102 VIN.n72 VIN.n71 4.5005
R103 VIN.n96 VIN.n95 4.5005
R104 VIN.n77 VIN.n76 4.5005
R105 VIN.n75 VIN.n72 4.5005
R106 VIN.n74 VIN.n73 4.5005
R107 VIN.n128 VIN.n127 4.5005
R108 VIN.n93 VIN.n89 4.5005
R109 VIN.n81 VIN.n80 4.5005
R110 VIN.n85 VIN.n84 4.5005
R111 VIN.n15 VIN.n14 4.5005
R112 VIN.n14 VIN.n13 4.5005
R113 VIN.n86 VIN.n85 4.5005
R114 VIN.n129 VIN.n128 4.5005
R115 VIN.n124 VIN.n123 4.5005
R116 VIN.n132 VIN.n121 4.5005
R117 VIN.n95 VIN.n94 4.5005
R118 VIN.n94 VIN.n5 4.5005
R119 VIN.n117 VIN.n116 4.5005
R120 VIN.n112 VIN.n111 4.5005
R121 VIN.n102 VIN.n101 4.5005
R122 VIN.n84 VIN.n83 4.5005
R123 VIN.n79 VIN.n78 4.5005
R124 VIN.n69 VIN.n68 4.5005
R125 VIN.n61 VIN.n16 4.5005
R126 VIN.n51 VIN.n50 4.5005
R127 VIN.n46 VIN.n45 4.5005
R128 VIN.n36 VIN.n35 4.5005
R129 VIN.n114 VIN.n113 4.5005
R130 VIN.n3 VIN.n2 4.5005
R131 VIN.n119 VIN.n118 4.5005
R132 VIN.n4 VIN.n3 4.5005
R133 VIN.n118 VIN.n117 4.5005
R134 VIN.n35 VIN.n34 4.5005
R135 VIN.n29 VIN.n28 4.5005
R136 VIN.n34 VIN.n33 4.5005
R137 VIN.n32 VIN.n29 4.5005
R138 VIN.n31 VIN.n30 4.5005
R139 VIN.n91 VIN.n90 4.5005
R140 VIN.n41 VIN.n40 4.5005
R141 VIN.n105 VIN.n104 4.5005
R142 VIN.n52 VIN.n51 4.5005
R143 VIN.n26 VIN.n25 4.5005
R144 VIN.n111 VIN.n110 4.5005
R145 VIN.n53 VIN.n52 4.5005
R146 VIN.n25 VIN.n24 4.5005
R147 VIN.n48 VIN.n47 4.5005
R148 VIN.n62 VIN.n61 4.5005
R149 VIN.n60 VIN.n56 4.5005
R150 VIN.n10 VIN.n9 4.5005
R151 VIN.n63 VIN.n62 4.5005
R152 VIN.n56 VIN.n55 4.5005
R153 VIN.n58 VIN.n57 4.5005
R154 VIN.n11 VIN.n8 4.5005
R155 VIN.n100 VIN.n99 4.5005
R156 VIN.n68 VIN.n67 4.5005
R157 VIN.n19 VIN.n18 4.5005
R158 VIN.n8 VIN.n7 4.5005
R159 VIN.n67 VIN.n66 4.5005
R160 VIN.n22 VIN.n19 4.5005
R161 VIN.n21 VIN.n20 4.5005
R162 VIN.n89 VIN.n88 4.5005
R163 VIN.n101 VIN.n100 4.5005
R164 VIN.n42 VIN.n39 4.5005
R165 VIN.n110 VIN.n109 4.5005
R166 VIN.n44 VIN.n43 4.5005
R167 VIN.n78 VIN.n77 4.5005
R168 VIN.n132 VIN.n0 3.28376
R169 VIN.n65 VIN.n12 2.8715
R170 VIN.n64 VIN.n54 2.8715
R171 VIN.n120 VIN.n1 2.5295
R172 VIN.n132 VIN.n131 2.27432
R173 VIN.n83 VIN.n82 2.21603
R174 VIN.n69 VIN.n17 2.21603
R175 VIN.n102 VIN.n6 2.21603
R176 VIN.n36 VIN.n27 2.21603
R177 VIN.n46 VIN.n37 2.21603
R178 VIN.n50 VIN.n49 2.21603
R179 VIN.n59 VIN.n16 2.21603
R180 VIN.n112 VIN.n103 2.21603
R181 VIN.n92 VIN.n5 2.21603
R182 VIN.n116 VIN.n115 2.21603
R183 VIN.n127 VIN.n126 2.21603
R184 VIN.n79 VIN.n70 2.21603
R185 VIN.n54 VIN.n23 2.0795
R186 VIN.n65 VIN.n64 2.0795
R187 VIN.n98 VIN.n97 1.8545
R188 VIN.n98 VIN.n1 1.5215
R189 VIN.n121 VIN.n120 1.454
R190 VIN.n116 VIN.n0 0.847054
R191 VIN.n83 VIN.n79 0.5605
R192 VIN.n83 VIN.n5 0.147167
R193 VIN.n128 VIN.n124 0.142605
R194 VIN.n35 VIN.n28 0.142605
R195 VIN.n34 VIN.n29 0.142605
R196 VIN.n30 VIN.n29 0.142605
R197 VIN.n45 VIN.n38 0.142605
R198 VIN.n44 VIN.n39 0.142605
R199 VIN.n40 VIN.n39 0.142605
R200 VIN.n51 VIN.n26 0.142605
R201 VIN.n52 VIN.n25 0.142605
R202 VIN.n48 VIN.n25 0.142605
R203 VIN.n62 VIN.n56 0.142605
R204 VIN.n58 VIN.n56 0.142605
R205 VIN.n68 VIN.n18 0.142605
R206 VIN.n67 VIN.n19 0.142605
R207 VIN.n20 VIN.n19 0.142605
R208 VIN.n78 VIN.n71 0.142605
R209 VIN.n77 VIN.n72 0.142605
R210 VIN.n73 VIN.n72 0.142605
R211 VIN.n84 VIN.n15 0.142605
R212 VIN.n85 VIN.n14 0.142605
R213 VIN.n81 VIN.n14 0.142605
R214 VIN.n101 VIN.n7 0.142605
R215 VIN.n100 VIN.n8 0.142605
R216 VIN.n9 VIN.n8 0.142605
R217 VIN.n111 VIN.n104 0.142605
R218 VIN.n110 VIN.n105 0.142605
R219 VIN.n106 VIN.n105 0.142605
R220 VIN.n117 VIN.n4 0.142605
R221 VIN.n118 VIN.n3 0.142605
R222 VIN.n114 VIN.n3 0.142605
R223 VIN.n94 VIN.n93 0.142605
R224 VIN.n95 VIN.n89 0.142605
R225 VIN.n91 VIN.n89 0.142605
R226 VIN.n61 VIN.n60 0.142605
R227 VIN.n79 VIN.n69 0.0855667
R228 VIN.n50 VIN.n16 0.0855667
R229 VIN.n46 VIN.n36 0.0855667
R230 VIN.n131 VIN.n130 0.079578
R231 VIN.n116 VIN.n112 0.0754333
R232 VIN.n115 VIN.n4 0.0709482
R233 VIN.n18 VIN.n17 0.0709482
R234 VIN.n28 VIN.n27 0.0709482
R235 VIN.n7 VIN.n6 0.0709482
R236 VIN.n38 VIN.n37 0.0709482
R237 VIN.n71 VIN.n70 0.0709482
R238 VIN.n93 VIN.n92 0.0709482
R239 VIN.n104 VIN.n103 0.0709482
R240 VIN.n60 VIN.n59 0.0709482
R241 VIN.n82 VIN.n15 0.0709482
R242 VIN.n49 VIN.n26 0.0709482
R243 VIN.n126 VIN.n124 0.0709482
R244 VIN.n130 VIN.n121 0.068
R245 VIN.n50 VIN.n46 0.0621
R246 VIN.n69 VIN.n16 0.0621
R247 VIN.n102 VIN.n5 0.0554333
R248 VIN.n99 VIN.n11 0.0545
R249 VIN.n11 VIN.n10 0.0545
R250 VIN.n47 VIN.n24 0.0545
R251 VIN.n53 VIN.n24 0.0545
R252 VIN.n42 VIN.n41 0.0545
R253 VIN.n43 VIN.n42 0.0545
R254 VIN.n32 VIN.n31 0.0545
R255 VIN.n33 VIN.n32 0.0545
R256 VIN.n109 VIN.n108 0.0545
R257 VIN.n108 VIN.n107 0.0545
R258 VIN.n96 VIN.n88 0.0545
R259 VIN.n90 VIN.n88 0.0545
R260 VIN.n119 VIN.n2 0.0545
R261 VIN.n113 VIN.n2 0.0545
R262 VIN.n22 VIN.n21 0.0545
R263 VIN.n66 VIN.n22 0.0545
R264 VIN.n57 VIN.n55 0.0545
R265 VIN.n125 VIN.n123 0.0545
R266 VIN.n75 VIN.n74 0.0545
R267 VIN.n63 VIN.n55 0.0545
R268 VIN.n129 VIN.n123 0.0545
R269 VIN.n76 VIN.n75 0.0545
R270 VIN.n86 VIN.n13 0.0545
R271 VIN.n80 VIN.n13 0.0545
R272 VIN.n112 VIN.n102 0.0455667
R273 VIN.n131 VIN.n122 0.0123666
R274 VIN.n127 VIN.n0 0.00877641
R275 VIN VIN.n132 0.006125
R276 VSS.n36 VSS.n7 3539.13
R277 VSS.n93 VSS.n6 621.611
R278 VSS.n53 VSS.n9 621.444
R279 VSS.n94 VSS.n5 621.444
R280 VSS.n90 VSS.n9 621.444
R281 VSS.n6 VSS.n5 621.444
R282 VSS.n90 VSS.n8 621.444
R283 VSS.n53 VSS.n8 621.444
R284 VSS.n55 VSS.n54 458.818
R285 VSS.n92 VSS.n91 316.796
R286 VSS.n54 VSS.t6 188.69
R287 VSS.t4 VSS.n92 188.69
R288 VSS.n94 VSS.n93 144.732
R289 VSS.n91 VSS.n7 125.584
R290 VSS.t6 VSS.n7 63.1073
R291 VSS.n55 VSS.t2 33.7241
R292 VSS.n36 VSS.t0 26.427
R293 VSS.n44 VSS.n33 21.1209
R294 VSS.n83 VSS.n82 20.1989
R295 VSS.n70 VSS.n69 20.1989
R296 VSS.n59 VSS.n13 20.1989
R297 VSS.n46 VSS.n45 20.1989
R298 VSS.n100 VSS.n99 20.1989
R299 VSS.n44 VSS.n43 20.1989
R300 VSS.n81 VSS.n80 20.1989
R301 VSS.n45 VSS.n44 17.942
R302 VSS.n74 VSS.t5 6.49753
R303 VSS.n63 VSS.t7 6.49753
R304 VSS.n95 VSS.n94 6.42734
R305 VSS.n90 VSS.n89 6.42734
R306 VSS.n27 VSS.t1 5.82998
R307 VSS.n57 VSS.n55 5.33341
R308 VSS.n22 VSS.t3 5.28723
R309 VSS.n37 VSS.n36 5.03525
R310 VSS.n88 VSS.n87 4.57095
R311 VSS.n29 VSS.n28 4.57095
R312 VSS.n65 VSS.n64 4.57095
R313 VSS.n96 VSS.n95 4.57095
R314 VSS.n56 VSS.n50 4.57095
R315 VSS.n76 VSS.n75 4.57095
R316 VSS.n21 VSS.n18 4.57095
R317 VSS.n42 VSS.n41 4.57095
R318 VSS.n102 VSS.n1 4.5005
R319 VSS.n98 VSS.n97 4.5005
R320 VSS.n99 VSS.n98 4.5005
R321 VSS.n4 VSS.n3 4.5005
R322 VSS.n43 VSS.n42 4.5005
R323 VSS.n35 VSS.n34 4.5005
R324 VSS.n38 VSS.n37 4.5005
R325 VSS.n39 VSS.n38 4.5005
R326 VSS.n40 VSS.n35 4.5005
R327 VSS.n39 VSS.n17 4.5005
R328 VSS.n85 VSS.n12 4.5005
R329 VSS.n67 VSS.n66 4.5005
R330 VSS.n62 VSS.n61 4.5005
R331 VSS.n49 VSS.n48 4.5005
R332 VSS.n31 VSS.n30 4.5005
R333 VSS.n32 VSS.n31 4.5005
R334 VSS.n26 VSS.n25 4.5005
R335 VSS.n33 VSS.n32 4.5005
R336 VSS.n25 VSS.n24 4.5005
R337 VSS.n28 VSS.n27 4.5005
R338 VSS.n48 VSS.n47 4.5005
R339 VSS.n20 VSS.n19 4.5005
R340 VSS.n47 VSS.n46 4.5005
R341 VSS.n23 VSS.n20 4.5005
R342 VSS.n22 VSS.n21 4.5005
R343 VSS.n61 VSS.n60 4.5005
R344 VSS.n52 VSS.n51 4.5005
R345 VSS.n60 VSS.n59 4.5005
R346 VSS.n58 VSS.n52 4.5005
R347 VSS.n57 VSS.n56 4.5005
R348 VSS.n68 VSS.n67 4.5005
R349 VSS.n16 VSS.n15 4.5005
R350 VSS.n69 VSS.n68 4.5005
R351 VSS.n15 VSS.n14 4.5005
R352 VSS.n64 VSS.n63 4.5005
R353 VSS.n85 VSS.n84 4.5005
R354 VSS.n86 VSS.n11 4.5005
R355 VSS.n84 VSS.n83 4.5005
R356 VSS.n11 VSS.n10 4.5005
R357 VSS.n89 VSS.n88 4.5005
R358 VSS.n79 VSS.n78 4.5005
R359 VSS.n73 VSS.n72 4.5005
R360 VSS.n80 VSS.n79 4.5005
R361 VSS.n72 VSS.n71 4.5005
R362 VSS.n75 VSS.n74 4.5005
R363 VSS.n78 VSS.n77 4.5005
R364 VSS.n102 VSS.n0 3.73376
R365 VSS.n70 VSS.n13 2.9795
R366 VSS.n82 VSS.n70 2.8715
R367 VSS.n81 VSS.n1 2.804
R368 VSS.n102 VSS.n101 2.27432
R369 VSS.n49 VSS.n18 2.21603
R370 VSS.n62 VSS.n50 2.21603
R371 VSS.n66 VSS.n65 2.21603
R372 VSS.n87 VSS.n12 2.21603
R373 VSS.n30 VSS.n29 2.21603
R374 VSS.n77 VSS.n76 2.21603
R375 VSS.n41 VSS.n17 2.21603
R376 VSS.n97 VSS.n96 2.21603
R377 VSS.n82 VSS.n81 2.0795
R378 VSS.n45 VSS.n13 0.959
R379 VSS.n77 VSS.n0 0.887054
R380 VSS.n49 VSS.n17 0.5321
R381 VSS.t6 VSS.n8 0.217167
R382 VSS.t6 VSS.n9 0.217167
R383 VSS.t4 VSS.n5 0.217167
R384 VSS.n32 VSS.n25 0.142605
R385 VSS.n28 VSS.n25 0.142605
R386 VSS.n48 VSS.n19 0.142605
R387 VSS.n84 VSS.n11 0.142605
R388 VSS.n88 VSS.n11 0.142605
R389 VSS.n47 VSS.n20 0.142605
R390 VSS.n21 VSS.n20 0.142605
R391 VSS.n98 VSS.n4 0.142605
R392 VSS.n61 VSS.n51 0.142605
R393 VSS.n60 VSS.n52 0.142605
R394 VSS.n56 VSS.n52 0.142605
R395 VSS.n78 VSS.n73 0.142605
R396 VSS.n67 VSS.n16 0.142605
R397 VSS.n68 VSS.n15 0.142605
R398 VSS.n42 VSS.n35 0.142605
R399 VSS.n38 VSS.n35 0.142605
R400 VSS.n64 VSS.n15 0.142605
R401 VSS.n40 VSS.n39 0.142605
R402 VSS.n79 VSS.n72 0.142605
R403 VSS.n31 VSS.n26 0.142605
R404 VSS.n86 VSS.n85 0.142605
R405 VSS.n75 VSS.n72 0.142605
R406 VSS.n66 VSS.n62 0.0887667
R407 VSS.n66 VSS.n12 0.0855667
R408 VSS.n101 VSS.n100 0.079578
R409 VSS.n76 VSS.n73 0.0709482
R410 VSS.n65 VSS.n16 0.0709482
R411 VSS.n19 VSS.n18 0.0709482
R412 VSS.n29 VSS.n26 0.0709482
R413 VSS.n51 VSS.n50 0.0709482
R414 VSS.n87 VSS.n86 0.0709482
R415 VSS.n41 VSS.n40 0.0709482
R416 VSS.n96 VSS.n4 0.0709482
R417 VSS.n100 VSS.n1 0.068
R418 VSS.n77 VSS.n12 0.0621
R419 VSS.n37 VSS.n34 0.0545
R420 VSS.n99 VSS.n3 0.0545
R421 VSS.n23 VSS.n22 0.0545
R422 VSS.n46 VSS.n23 0.0545
R423 VSS.n69 VSS.n14 0.0545
R424 VSS.n83 VSS.n10 0.0545
R425 VSS.n63 VSS.n14 0.0545
R426 VSS.n74 VSS.n71 0.0545
R427 VSS.n95 VSS.n3 0.0545
R428 VSS.n80 VSS.n71 0.0545
R429 VSS.n59 VSS.n58 0.0545
R430 VSS.n58 VSS.n57 0.0545
R431 VSS.n89 VSS.n10 0.0545
R432 VSS.n43 VSS.n34 0.0545
R433 VSS.n93 VSS.t4 0.0514603
R434 VSS.n91 VSS.n90 0.0477727
R435 VSS.n54 VSS.n53 0.0477727
R436 VSS.n92 VSS.n6 0.0477727
R437 VSS.n27 VSS.n24 0.0458782
R438 VSS.n33 VSS.n24 0.0458782
R439 VSS.n30 VSS.n17 0.0319
R440 VSS.n62 VSS.n49 0.0289
R441 VSS.n101 VSS.n2 0.0123666
R442 VSS.n97 VSS.n0 0.00877641
R443 VSS VSS.n102 0.006125
R444 IN1.n0 IN1.t3 72.6175
R445 IN1.n0 IN1.t1 67.6675
R446 IN1.n4 IN1.n3 39.5775
R447 IN1.n1 IN1.t2 33.7243
R448 IN1.n4 IN1.n1 9.9005
R449 IN1.n1 IN1.n0 1.184
R450 IN1 IN1.n4 0.068
R451 IN1.n3 IN1.t0 0.0187
R452 IN1.n3 IN1.n2 0.0131
R453 ITAIL.n0 ITAIL.t0 45.0194
R454 ITAIL.n0 ITAIL.t1 40.0694
R455 ITAIL.n3 ITAIL.n2 30.6769
R456 ITAIL.n3 ITAIL.n0 5.7425
R457 ITAIL.n2 ITAIL.t2 0.0915
R458 ITAIL ITAIL.n3 0.068
R459 ITAIL.n2 ITAIL.n1 0.0635
C0 DISABLE VSS 7.2798300000000006e-15
C1 ICTRL VSS 4.1860800000000005e-14
C2 IN1 VSS 4.4944200000000003e-14
C3 IN2 VSS 2.6967000000000001e-14
C4 IOUT VSS 2.2306600000000002e-14
C5 IPB VSS 1.5753400000000002e-14
C6 ITAIL VSS 2.1256400000000004e-14
C7 SENSE VSS 1.9663700000000001e-14
C8 VIN VSS 9.6885700000000006e-13
C9 VSET VSS 9.3812999999999996e-15
C10 ITAIL SENSE 5.6079499999999999e-15
C11 VSET IN1 5.6066000000000008e-15
C12 VIN ITAIL 2.3445200000000003e-14
C13 SENSE ICTRL 5.7641700000000007e-15
C14 VIN ICTRL 4.2531300000000009e-14
C15 IOUT DISABLE 1.2698399999999999e-15
C16 ITAIL IN2 1.2982000000000001e-16
C17 IPB ITAIL 1.37509e-15
C18 VIN VSET 4.3379399999999996e-15
C19 IN2 ICTRL 1.1530500000000001e-15
C20 VIN IOUT 1.42834e-14
C21 IN1 SENSE 6.9340500000000005e-17
C22 VIN IN1 1.2538800000000001e-14
C23 IN1 IN2 3.1280100000000005e-15
C24 ITAIL VSET 5.608930000000001e-15
C25 VIN SENSE 1.6116700000000003e-14
C26 ICTRL IOUT 7.1750200000000012e-15
C27 SENSE IN2 6.0057500000000002e-15
C28 ITAIL IN1 6.9786699999999999e-16
C29 VIN IN2 1.2069800000000001e-14
C30 VIN IPB 1.2211700000000002e-14
.ends nrz_vi_reference
