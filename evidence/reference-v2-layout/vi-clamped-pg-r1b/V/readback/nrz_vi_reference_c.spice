* NGSPICE file created from nrz_vi_reference.ext - technology: gf180mcuD

.subckt nrz_vi_reference VIN VSS VSET SENSE IOUT IPB IN2 ICTRL DISABLE
X0 VSS IN1 IN2 VSS nfet_06v0 ad=22p pd=0.10088m as=22p ps=0.10088m w=50u l=10u
X1 VSS IN1 IN1 VSS nfet_06v0 ad=22p pd=0.10088m as=22p ps=0.10088m w=50u l=10u
X2 VIN ICTRL IOUT VIN pfet_06v0 ad=44p pd=0.20088m as=44p ps=0.20088m w=100u l=10u
X3 VIN ICTRL ICTRL VIN pfet_06v0 ad=44p pd=0.20088m as=44p ps=0.20088m w=100u l=10u
X4 VSS DISABLE IOUT VSS nfet_06v0 ad=4.4p pd=20.88u as=4.4p ps=20.88u w=10u l=0.7u
X5 ITAIL SENSE IN2 VIN pfet_06v0 ad=44p pd=0.20088m as=44p ps=0.20088m w=100u l=10u
X6 VSS IN2 ICTRL VSS nfet_06v0 ad=8.8p pd=40.88u as=8.8p ps=40.88u w=20u l=1u
X7 VIN IPB IPB VIN pfet_06v0 ad=8.8p pd=40.88u as=8.8p ps=40.88u w=20u l=4u
X8 VIN ICTRL SENSE VIN pfet_06v0 ad=44p pd=0.20088m as=44p ps=0.20088m w=100u l=10u
X9 ITAIL VSET IN1 VIN pfet_06v0 ad=44p pd=0.20088m as=44p ps=0.20088m w=100u l=10u
X10 VIN IPB ITAIL VIN pfet_06v0 ad=8.8p pd=40.88u as=8.8p ps=40.88u w=20u l=4u
C0 SENSE IN2 6.00575f
C1 ITAIL VSET 5.60893f
C2 VIN IOUT 14.2834f
C3 ITAIL IPB 1.37509f
C4 IN1 VIN 12.5388f
C5 IOUT DISABLE 1.26984f
C6 VIN ICTRL 42.5313f
C7 ITAIL VIN 23.4452f
C8 VIN IN2 12.0698f
C9 ICTRL IOUT 7.17502f
C10 VIN SENSE 16.1167f
C11 ITAIL IN1 0.69787f
C12 VIN VSET 4.33794f
C13 IN1 IN2 3.12801f
C14 IN2 ICTRL 1.15305f
C15 ITAIL IN2 0.12982f
C16 IN1 SENSE 0.06934f
C17 VIN IPB 12.2117f
C18 SENSE ICTRL 5.76417f
C19 ITAIL SENSE 5.60795f
C20 IN1 VSET 5.6066f
C21 IOUT VSS 46.87691f
C22 SENSE VSS 14.81774f
C23 VIN VSS 1.01248p
C24 IN1 VSS 4.69065f
C25 ITAIL VSS 35.7789f
.ends
