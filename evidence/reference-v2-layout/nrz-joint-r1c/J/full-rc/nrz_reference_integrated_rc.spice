* Audited RC model assembly from build/reference-v2-layout/nrz-joint-r1c/J/readback/nrz_reference_integrated.ext.
* Original Magic RC preserved in ../unmodified-full-rc/.
* R/MOS unchanged; C counted once with post-simplification allocation weights.
* Coupling remains at original logical nodes; no EM claim.
.subckt nrz_reference_integrated DATA OUT VDD VSS BIAS DUMMY VIN VSET SENSE IPB IN2 ICTRL DISABLE
X0 VSS.t12 DI.t2 GB.t1 VSS.t11 nfet_06v0 ad=1.1p pd=5.88u as=1.1p ps=5.88u w=2.5u l=0.7u
X1 VIN.t3 ICTRL.t0 ICTRL.t1 VIN.t2 pfet_06v0 ad=44p pd=0.20088m as=44p ps=0.20088m w=100u l=10u
X2 VIN.t1 ICTRL.t3 BIAS.t3 VIN.t0 pfet_06v0 ad=44p pd=0.20088m as=44p ps=0.20088m w=100u l=10u
X3 DI.t0 DATA.t0 VSS.t10 ppolyf_u_1k_6p0 r_width=1u r_length=58u
X4 VX.t1 GB.t2 DUMMY.t0 VSS.t17 nfet_06v0 ad=1.1p pd=5.88u as=1.1p ps=5.88u w=2.5u l=0.7u
X5 VIN.t11 IPB.t0 IPB.t1 VIN.t10 pfet_06v0 ad=8.8p pd=40.88u as=8.8p ps=40.88u w=20u l=4u
X6 VSS.t1 DISABLE.t0 BIAS.t0 VSS.t0 nfet_06v0 ad=4.4p pd=20.88u as=4.4p ps=20.88u w=10u l=0.7u
X7 ITAIL.t0 SENSE.t1 IN2.t1 VIN.t6 pfet_06v0 ad=44p pd=0.20088m as=44p ps=0.20088m w=100u l=10u
X8 VSS.t9 IN2.t2 ICTRL.t2 VSS.t8 nfet_06v0 ad=8.8p pd=40.88u as=8.8p ps=40.88u w=20u l=1u
X9 ITAIL.t1 VSET.t0 IN1.t0 VIN.t7 pfet_06v0 ad=44p pd=0.20088m as=44p ps=0.20088m w=100u l=10u
X10 VIN.t9 IPB.t2 ITAIL.t2 VIN.t8 pfet_06v0 ad=8.8p pd=40.88u as=8.8p ps=40.88u w=20u l=4u
X11 VSS.t5 BIAS.t4 OUT.t1 VSS.t4 nfet_03v3 ad=0.88p pd=4.88u as=0.88p ps=4.88u w=2u l=1u
X12 VIN.t5 ICTRL.t4 SENSE.t0 VIN.t4 pfet_06v0 ad=44p pd=0.20088m as=44p ps=0.20088m w=100u l=10u
X13 VX.t2 GP.t2 OUT.t0 VSS.t20 nfet_06v0 ad=1.1p pd=5.88u as=1.1p ps=5.88u w=2.5u l=0.7u
X14 VDD.t1 DI.t1 GB.t0 VDD.t0 pfet_06v0 ad=1.7292p pd=8.74u as=1.7292p ps=8.74u w=3.93u l=0.55u
X15 VSS.t16 IN1.t3 IN2.t0 VSS.t15 nfet_06v0 ad=22p pd=0.10088m as=22p ps=0.10088m w=50u l=10u
X16 VSS.t7 BIAS.t5 VX.t0 VSS.t6 nfet_03v3 ad=2.5344p pd=12.4u as=2.5344p ps=12.4u w=5.76u l=1u
X17 VSS.t3 BIAS.t1 BIAS.t2 VSS.t2 nfet_03v3 ad=0.88p pd=4.88u as=0.88p ps=4.88u w=2u l=1u
X18 VSS.t19 GB.t4 GP.t0 VSS.t18 nfet_06v0 ad=1.1p pd=5.88u as=1.1p ps=5.88u w=2.5u l=0.7u
X19 VSS.t14 IN1.t1 IN1.t2 VSS.t13 nfet_06v0 ad=22p pd=0.10088m as=22p ps=0.10088m w=50u l=10u
X20 VDD.t3 GB.t3 GP.t1 VDD.t2 pfet_06v0 ad=1.7292p pd=8.74u as=1.7292p ps=8.74u w=3.93u l=0.55u
R0 DUMMY DUMMY.t0 14.0846
R1 OUT.n0 OUT.t1 19.6265
R2 OUT.n0 OUT.t0 15.1315
R3 OUT OUT.n0 0.0905
R4 DATA DATA.t0 16.4663
R5 DISABLE DISABLE.t0 105.593
R6 BIAS.n25 BIAS.t5 42.1745
R7 BIAS.n23 BIAS.t1 36.8399
R8 BIAS.n24 BIAS.t4 36.6689
R9 BIAS.n11 BIAS.n10 27.0723
R10 BIAS.n20 BIAS.n19 21.1463
R11 BIAS.n23 BIAS.t2 14.7577
R12 BIAS BIAS.n25 9.50549
R13 BIAS.n15 BIAS.t3 7.79795
R14 BIAS.n4 BIAS.t0 4.70498
R15 BIAS.n6 BIAS.n5 4.57095
R16 BIAS.n16 BIAS.n15 4.57095
R17 BIAS.n9 BIAS.n8 4.5005
R18 BIAS.n18 BIAS.n17 4.5005
R19 BIAS.n5 BIAS.n4 4.5005
R20 BIAS.n19 BIAS.n18 4.5005
R21 BIAS.n14 BIAS.n13 4.5005
R22 BIAS.n2 BIAS.n1 4.5005
R23 BIAS.n10 BIAS.n9 4.5005
R24 BIAS.n3 BIAS.n2 4.5005
R25 BIAS.n22 BIAS.n11 4.5005
R26 BIAS.n8 BIAS.n7 4.5005
R27 BIAS.n22 BIAS.n0 3.95876
R28 BIAS.n25 BIAS.n24 3.77746
R29 BIAS.n22 BIAS.n21 2.27432
R30 BIAS.n7 BIAS.n6 2.21603
R31 BIAS.n17 BIAS.n16 2.21603
R32 BIAS.n24 BIAS.n23 1.1795
R33 BIAS.n7 BIAS.n0 0.975654
R34 BIAS.n18 BIAS.n14 0.142605
R35 BIAS.n8 BIAS.n3 0.142605
R36 BIAS.n9 BIAS.n2 0.142605
R37 BIAS.n5 BIAS.n2 0.142605
R38 BIAS.n21 BIAS.n20 0.079578
R39 BIAS.n6 BIAS.n3 0.0709482
R40 BIAS.n16 BIAS.n14 0.0709482
R41 BIAS.n20 BIAS.n11 0.068
R42 BIAS.n15 BIAS.n13 0.0545
R43 BIAS.n19 BIAS.n13 0.0545
R44 BIAS.n10 BIAS.n1 0.0458782
R45 BIAS.n4 BIAS.n1 0.0458782
R46 BIAS.n21 BIAS.n12 0.0123666
R47 BIAS.n17 BIAS.n0 0.00877641
R48 BIAS BIAS.n22 0.006125
R49 ICTRL.n0 ICTRL.t3 104.13
R50 ICTRL.n0 ICTRL.t4 99.1807
R51 ICTRL.n1 ICTRL.t0 99.1807
R52 ICTRL.n2 ICTRL.t1 41.0168
R53 ICTRL.n3 ICTRL.t2 31.7324
R54 ICTRL.n1 ICTRL.n0 4.9505
R55 ICTRL.n3 ICTRL.n2 3.038
R56 ICTRL.n2 ICTRL.n1 1.184
R57 ICTRL ICTRL.n3 0.0905
R58 IN2.n0 IN2.t2 130.244
R59 IN2.n1 IN2.t1 41.4905
R60 IN2.n0 IN2.t0 35.619
R61 IN2.n1 IN2.n0 9.9005
R62 IN2 IN2.n1 0.0905
R63 SENSE.n0 SENSE.t1 101.076
R64 SENSE.n0 SENSE.t0 65.578
R65 SENSE SENSE.n0 0.0905
R66 VSET VSET.t0 101.639
R67 IPB.n0 IPB.t2 68.1472
R68 IPB.n0 IPB.t0 64.0972
R69 IPB.n1 IPB.t1 32.6627
R70 IPB.n1 IPB.n0 0.509
R71 IPB IPB.n1 0.0905
R72 VDD.n2 VDD.t0 119.847
R73 VDD.n0 VDD.t2 119.847
R74 VDD.n0 VDD.t3 14.7281
R75 VDD.n1 VDD.t1 14.0452
R76 VDD.n1 VDD.n0 2.01762
R77 VDD.n2 VDD.n1 0.683375
R78 VDD VDD.n2 0.0905
R79 VIN.n107 VIN.t8 102.373
R80 VIN.n125 VIN.t10 102.373
R81 VIN.n74 VIN.t2 64.616
R82 VIN.n41 VIN.t0 64.616
R83 VIN.n57 VIN.t4 64.616
R84 VIN.n90 VIN.t7 64.616
R85 VIN.n80 VIN.t6 64.616
R86 VIN.n33 VIN.n23 21.1752
R87 VIN.n87 VIN.n12 18.9005
R88 VIN.n120 VIN.n119 18.3042
R89 VIN.n109 VIN.n1 18.3042
R90 VIN.n54 VIN.n53 18.3042
R91 VIN.n130 VIN.n129 18.3042
R92 VIN.n97 VIN.n96 18.3042
R93 VIN.n43 VIN.n23 18.3042
R94 VIN.n99 VIN.n98 18.3042
R95 VIN.n76 VIN.n12 18.3042
R96 VIN.n66 VIN.n65 18.3042
R97 VIN.n64 VIN.n63 18.3042
R98 VIN.n87 VIN.n86 18.3042
R99 VIN.n21 VIN.t3 9.59795
R100 VIN.n47 VIN.t5 9.59795
R101 VIN.n31 VIN.t1 9.59795
R102 VIN.n113 VIN.t11 6.17014
R103 VIN.n10 VIN.t9 6.17014
R104 VIN.n97 VIN.n87 4.9505
R105 VIN.n115 VIN.n114 4.57095
R106 VIN.n40 VIN.n37 4.57095
R107 VIN.n126 VIN.n125 4.57095
R108 VIN.n9 VIN.n6 4.57095
R109 VIN.n49 VIN.n48 4.57095
R110 VIN.n73 VIN.n70 4.57095
R111 VIN.n92 VIN.n91 4.57095
R112 VIN.n20 VIN.n17 4.57095
R113 VIN.n82 VIN.n81 4.57095
R114 VIN.n59 VIN.n58 4.57095
R115 VIN.n30 VIN.n27 4.57095
R116 VIN.n106 VIN.n103 4.57095
R117 VIN.n107 VIN.n106 4.5005
R118 VIN.n108 VIN.n105 4.5005
R119 VIN.n45 VIN.n44 4.5005
R120 VIN.n39 VIN.n38 4.5005
R121 VIN.n72 VIN.n71 4.5005
R122 VIN.n96 VIN.n95 4.5005
R123 VIN.n77 VIN.n76 4.5005
R124 VIN.n75 VIN.n72 4.5005
R125 VIN.n74 VIN.n73 4.5005
R126 VIN.n128 VIN.n127 4.5005
R127 VIN.n93 VIN.n89 4.5005
R128 VIN.n81 VIN.n80 4.5005
R129 VIN.n85 VIN.n84 4.5005
R130 VIN.n15 VIN.n14 4.5005
R131 VIN.n14 VIN.n13 4.5005
R132 VIN.n86 VIN.n85 4.5005
R133 VIN.n129 VIN.n128 4.5005
R134 VIN.n124 VIN.n123 4.5005
R135 VIN.n132 VIN.n121 4.5005
R136 VIN.n95 VIN.n94 4.5005
R137 VIN.n94 VIN.n5 4.5005
R138 VIN.n117 VIN.n116 4.5005
R139 VIN.n112 VIN.n111 4.5005
R140 VIN.n102 VIN.n101 4.5005
R141 VIN.n84 VIN.n83 4.5005
R142 VIN.n79 VIN.n78 4.5005
R143 VIN.n69 VIN.n68 4.5005
R144 VIN.n61 VIN.n16 4.5005
R145 VIN.n51 VIN.n50 4.5005
R146 VIN.n46 VIN.n45 4.5005
R147 VIN.n36 VIN.n35 4.5005
R148 VIN.n114 VIN.n113 4.5005
R149 VIN.n3 VIN.n2 4.5005
R150 VIN.n119 VIN.n118 4.5005
R151 VIN.n4 VIN.n3 4.5005
R152 VIN.n118 VIN.n117 4.5005
R153 VIN.n35 VIN.n34 4.5005
R154 VIN.n29 VIN.n28 4.5005
R155 VIN.n34 VIN.n33 4.5005
R156 VIN.n32 VIN.n29 4.5005
R157 VIN.n31 VIN.n30 4.5005
R158 VIN.n91 VIN.n90 4.5005
R159 VIN.n41 VIN.n40 4.5005
R160 VIN.n105 VIN.n104 4.5005
R161 VIN.n52 VIN.n51 4.5005
R162 VIN.n26 VIN.n25 4.5005
R163 VIN.n111 VIN.n110 4.5005
R164 VIN.n53 VIN.n52 4.5005
R165 VIN.n25 VIN.n24 4.5005
R166 VIN.n48 VIN.n47 4.5005
R167 VIN.n62 VIN.n61 4.5005
R168 VIN.n60 VIN.n56 4.5005
R169 VIN.n10 VIN.n9 4.5005
R170 VIN.n63 VIN.n62 4.5005
R171 VIN.n56 VIN.n55 4.5005
R172 VIN.n58 VIN.n57 4.5005
R173 VIN.n11 VIN.n8 4.5005
R174 VIN.n100 VIN.n99 4.5005
R175 VIN.n68 VIN.n67 4.5005
R176 VIN.n19 VIN.n18 4.5005
R177 VIN.n8 VIN.n7 4.5005
R178 VIN.n67 VIN.n66 4.5005
R179 VIN.n22 VIN.n19 4.5005
R180 VIN.n21 VIN.n20 4.5005
R181 VIN.n89 VIN.n88 4.5005
R182 VIN.n101 VIN.n100 4.5005
R183 VIN.n42 VIN.n39 4.5005
R184 VIN.n110 VIN.n109 4.5005
R185 VIN.n44 VIN.n43 4.5005
R186 VIN.n78 VIN.n77 4.5005
R187 VIN.n132 VIN.n0 3.28376
R188 VIN.n65 VIN.n12 2.8715
R189 VIN.n64 VIN.n54 2.8715
R190 VIN.n120 VIN.n1 2.5295
R191 VIN.n132 VIN.n131 2.27432
R192 VIN.n83 VIN.n82 2.21603
R193 VIN.n69 VIN.n17 2.21603
R194 VIN.n102 VIN.n6 2.21603
R195 VIN.n36 VIN.n27 2.21603
R196 VIN.n46 VIN.n37 2.21603
R197 VIN.n50 VIN.n49 2.21603
R198 VIN.n59 VIN.n16 2.21603
R199 VIN.n112 VIN.n103 2.21603
R200 VIN.n92 VIN.n5 2.21603
R201 VIN.n116 VIN.n115 2.21603
R202 VIN.n127 VIN.n126 2.21603
R203 VIN.n79 VIN.n70 2.21603
R204 VIN.n54 VIN.n23 2.0795
R205 VIN.n65 VIN.n64 2.0795
R206 VIN.n98 VIN.n97 1.8545
R207 VIN.n98 VIN.n1 1.5215
R208 VIN.n121 VIN.n120 1.454
R209 VIN.n116 VIN.n0 0.847054
R210 VIN.n83 VIN.n79 0.5605
R211 VIN.n83 VIN.n5 0.147167
R212 VIN.n128 VIN.n124 0.142605
R213 VIN.n35 VIN.n28 0.142605
R214 VIN.n34 VIN.n29 0.142605
R215 VIN.n30 VIN.n29 0.142605
R216 VIN.n45 VIN.n38 0.142605
R217 VIN.n44 VIN.n39 0.142605
R218 VIN.n40 VIN.n39 0.142605
R219 VIN.n51 VIN.n26 0.142605
R220 VIN.n52 VIN.n25 0.142605
R221 VIN.n48 VIN.n25 0.142605
R222 VIN.n62 VIN.n56 0.142605
R223 VIN.n58 VIN.n56 0.142605
R224 VIN.n68 VIN.n18 0.142605
R225 VIN.n67 VIN.n19 0.142605
R226 VIN.n20 VIN.n19 0.142605
R227 VIN.n78 VIN.n71 0.142605
R228 VIN.n77 VIN.n72 0.142605
R229 VIN.n73 VIN.n72 0.142605
R230 VIN.n84 VIN.n15 0.142605
R231 VIN.n85 VIN.n14 0.142605
R232 VIN.n81 VIN.n14 0.142605
R233 VIN.n101 VIN.n7 0.142605
R234 VIN.n100 VIN.n8 0.142605
R235 VIN.n9 VIN.n8 0.142605
R236 VIN.n111 VIN.n104 0.142605
R237 VIN.n110 VIN.n105 0.142605
R238 VIN.n106 VIN.n105 0.142605
R239 VIN.n117 VIN.n4 0.142605
R240 VIN.n118 VIN.n3 0.142605
R241 VIN.n114 VIN.n3 0.142605
R242 VIN.n94 VIN.n93 0.142605
R243 VIN.n95 VIN.n89 0.142605
R244 VIN.n91 VIN.n89 0.142605
R245 VIN.n61 VIN.n60 0.142605
R246 VIN.n79 VIN.n69 0.0855667
R247 VIN.n50 VIN.n16 0.0855667
R248 VIN.n46 VIN.n36 0.0855667
R249 VIN.n131 VIN.n130 0.079578
R250 VIN.n116 VIN.n112 0.0754333
R251 VIN.n115 VIN.n4 0.0709482
R252 VIN.n18 VIN.n17 0.0709482
R253 VIN.n28 VIN.n27 0.0709482
R254 VIN.n7 VIN.n6 0.0709482
R255 VIN.n38 VIN.n37 0.0709482
R256 VIN.n71 VIN.n70 0.0709482
R257 VIN.n93 VIN.n92 0.0709482
R258 VIN.n104 VIN.n103 0.0709482
R259 VIN.n60 VIN.n59 0.0709482
R260 VIN.n82 VIN.n15 0.0709482
R261 VIN.n49 VIN.n26 0.0709482
R262 VIN.n126 VIN.n124 0.0709482
R263 VIN.n130 VIN.n121 0.068
R264 VIN.n50 VIN.n46 0.0621
R265 VIN.n69 VIN.n16 0.0621
R266 VIN.n102 VIN.n5 0.0554333
R267 VIN.n99 VIN.n11 0.0545
R268 VIN.n11 VIN.n10 0.0545
R269 VIN.n47 VIN.n24 0.0545
R270 VIN.n53 VIN.n24 0.0545
R271 VIN.n42 VIN.n41 0.0545
R272 VIN.n43 VIN.n42 0.0545
R273 VIN.n32 VIN.n31 0.0545
R274 VIN.n33 VIN.n32 0.0545
R275 VIN.n109 VIN.n108 0.0545
R276 VIN.n108 VIN.n107 0.0545
R277 VIN.n96 VIN.n88 0.0545
R278 VIN.n90 VIN.n88 0.0545
R279 VIN.n119 VIN.n2 0.0545
R280 VIN.n113 VIN.n2 0.0545
R281 VIN.n22 VIN.n21 0.0545
R282 VIN.n66 VIN.n22 0.0545
R283 VIN.n57 VIN.n55 0.0545
R284 VIN.n125 VIN.n123 0.0545
R285 VIN.n75 VIN.n74 0.0545
R286 VIN.n63 VIN.n55 0.0545
R287 VIN.n129 VIN.n123 0.0545
R288 VIN.n76 VIN.n75 0.0545
R289 VIN.n86 VIN.n13 0.0545
R290 VIN.n80 VIN.n13 0.0545
R291 VIN.n112 VIN.n102 0.0455667
R292 VIN.n131 VIN.n122 0.0123666
R293 VIN.n127 VIN.n0 0.00877641
R294 VIN VIN.n132 0.006125
R295 VSS.n133 VSS.n107 16199.6
R296 VSS.n107 VSS.n106 1936.14
R297 VSS.n106 VSS.n5 1560.29
R298 VSS.n144 VSS.t18 945.197
R299 VSS.t18 VSS.n4 896.018
R300 VSS.n77 VSS.n76 621.611
R301 VSS.n104 VSS.n8 621.444
R302 VSS.n104 VSS.n7 621.444
R303 VSS.n78 VSS.n75 621.444
R304 VSS.n51 VSS.n7 621.444
R305 VSS.n76 VSS.n75 621.444
R306 VSS.n51 VSS.n8 621.444
R307 VSS.n142 VSS.n135 616.194
R308 VSS.n142 VSS.n138 616.194
R309 VSS.n136 VSS.n135 616.194
R310 VSS.n53 VSS.n52 458.818
R311 VSS.n134 VSS.n133 427.63
R312 VSS.n128 VSS.t18 342.058
R313 VSS.n4 VSS.t11 328.252
R314 VSS.n105 VSS.n6 316.796
R315 VSS.n144 VSS.n143 213.851
R316 VSS.t13 VSS.n6 188.69
R317 VSS.n52 VSS.t15 188.69
R318 VSS.n111 VSS.n107 187.679
R319 VSS.n78 VSS.n77 144.732
R320 VSS.n106 VSS.n105 125.584
R321 VSS.n121 VSS.n120 99.9027
R322 VSS.n143 VSS.t10 81.5237
R323 VSS.n137 VSS.n136 71.8966
R324 VSS.n125 VSS.n123 69.8005
R325 VSS.n131 VSS.n108 69.8005
R326 VSS.n113 VSS.n111 63.7434
R327 VSS.n118 VSS.n110 63.7434
R328 VSS.n106 VSS.t15 63.1073
R329 VSS.n124 VSS.n108 45.8061
R330 VSS.n123 VSS.n122 44.1603
R331 VSS.n112 VSS.n110 42.5146
R332 VSS.n120 VSS.n119 42.5146
R333 VSS.n133 VSS.n132 42.1718
R334 VSS.n53 VSS.t8 33.7241
R335 VSS.n5 VSS.t0 26.427
R336 VSS.n42 VSS.n32 21.1209
R337 VSS.n97 VSS.n96 20.1989
R338 VSS.n68 VSS.n67 20.1989
R339 VSS.n57 VSS.n12 20.1989
R340 VSS.n44 VSS.n43 20.1989
R341 VSS.n42 VSS.n41 20.1989
R342 VSS.n84 VSS.n83 20.1989
R343 VSS.n95 VSS.n94 20.1989
R344 VSS.n120 VSS.t6 19.8861
R345 VSS.n110 VSS.t4 19.8861
R346 VSS.n122 VSS.t6 19.8861
R347 VSS.t2 VSS.n111 19.8861
R348 VSS.n112 VSS.t2 19.8861
R349 VSS.n119 VSS.t4 19.8861
R350 VSS.n132 VSS.t20 18.2404
R351 VSS.n108 VSS.t20 18.2404
R352 VSS.t17 VSS.n123 18.2404
R353 VSS.n124 VSS.t17 18.2404
R354 VSS.n43 VSS.n42 17.942
R355 VSS.n114 VSS.t3 15.7754
R356 VSS.n115 VSS.t5 15.0419
R357 VSS.n129 VSS.t19 14.5631
R358 VSS.n127 VSS.t12 14.5631
R359 VSS.n4 VSS.n2 13.8073
R360 VSS.n118 VSS.n117 13.6394
R361 VSS.n114 VSS.n113 13.6394
R362 VSS.n131 VSS.n130 13.5028
R363 VSS.n126 VSS.n125 13.5028
R364 VSS.n116 VSS.t7 13.4572
R365 VSS.n121 VSS.n109 13.2432
R366 VSS.n145 VSS.n3 13.1668
R367 VSS.n141 VSS.n139 12.4264
R368 VSS.n141 VSS.n140 12.4264
R369 VSS.n140 VSS.n3 12.397
R370 VSS.n139 VSS.n3 12.397
R371 VSS.n135 VSS.n134 10.9571
R372 VSS VSS.n147 9.76043
R373 VSS.n145 VSS.n144 6.77158
R374 VSS.n88 VSS.t14 6.49753
R375 VSS.n61 VSS.t16 6.49753
R376 VSS.n104 VSS.n103 6.42734
R377 VSS.n79 VSS.n78 6.42734
R378 VSS.n26 VSS.t1 5.82998
R379 VSS.n55 VSS.n53 5.33341
R380 VSS.n21 VSS.t9 5.28723
R381 VSS.n35 VSS.n5 5.03525
R382 VSS.n79 VSS.n73 4.57095
R383 VSS.n40 VSS.n39 4.57095
R384 VSS.n28 VSS.n27 4.57095
R385 VSS.n20 VSS.n17 4.57095
R386 VSS.n63 VSS.n62 4.57095
R387 VSS.n102 VSS.n101 4.57095
R388 VSS.n90 VSS.n89 4.57095
R389 VSS.n54 VSS.n48 4.57095
R390 VSS.n22 VSS.n19 4.5005
R391 VSS.n45 VSS.n44 4.5005
R392 VSS.n92 VSS.n91 4.5005
R393 VSS.n99 VSS.n11 4.5005
R394 VSS.n65 VSS.n64 4.5005
R395 VSS.n60 VSS.n59 4.5005
R396 VSS.n47 VSS.n46 4.5005
R397 VSS.n30 VSS.n29 4.5005
R398 VSS.n19 VSS.n18 4.5005
R399 VSS.n46 VSS.n45 4.5005
R400 VSS.n27 VSS.n26 4.5005
R401 VSS.n24 VSS.n23 4.5005
R402 VSS.n32 VSS.n31 4.5005
R403 VSS.n25 VSS.n24 4.5005
R404 VSS.n31 VSS.n30 4.5005
R405 VSS.n89 VSS.n88 4.5005
R406 VSS.n71 VSS.n70 4.5005
R407 VSS.n94 VSS.n93 4.5005
R408 VSS.n72 VSS.n71 4.5005
R409 VSS.n69 VSS.n0 4.5005
R410 VSS.n93 VSS.n92 4.5005
R411 VSS.n86 VSS.n85 4.5005
R412 VSS.n103 VSS.n102 4.5005
R413 VSS.n147 VSS.n1 4.5005
R414 VSS.n10 VSS.n9 4.5005
R415 VSS.n98 VSS.n97 4.5005
R416 VSS.n100 VSS.n10 4.5005
R417 VSS.n99 VSS.n98 4.5005
R418 VSS.n62 VSS.n61 4.5005
R419 VSS.n14 VSS.n13 4.5005
R420 VSS.n67 VSS.n66 4.5005
R421 VSS.n15 VSS.n14 4.5005
R422 VSS.n66 VSS.n65 4.5005
R423 VSS.n55 VSS.n54 4.5005
R424 VSS.n56 VSS.n50 4.5005
R425 VSS.n58 VSS.n57 4.5005
R426 VSS.n41 VSS.n40 4.5005
R427 VSS.n34 VSS.n33 4.5005
R428 VSS.n36 VSS.n35 4.5005
R429 VSS.n50 VSS.n49 4.5005
R430 VSS.n85 VSS.n84 4.5005
R431 VSS.n59 VSS.n58 4.5005
R432 VSS.n37 VSS.n36 4.5005
R433 VSS.n38 VSS.n34 4.5005
R434 VSS.n80 VSS.n74 4.5005
R435 VSS.n21 VSS.n20 4.5005
R436 VSS.n37 VSS.n16 4.5005
R437 VSS.n87 VSS.n0 3.73376
R438 VSS.n68 VSS.n12 2.9795
R439 VSS.n96 VSS.n68 2.8715
R440 VSS.n95 VSS.n69 2.804
R441 VSS.n82 VSS.n0 2.27432
R442 VSS.n147 VSS.n146 2.21775
R443 VSS.n64 VSS.n63 2.21603
R444 VSS.n47 VSS.n17 2.21603
R445 VSS.n86 VSS.n73 2.21603
R446 VSS.n60 VSS.n48 2.21603
R447 VSS.n91 VSS.n90 2.21603
R448 VSS.n39 VSS.n16 2.21603
R449 VSS.n101 VSS.n11 2.21603
R450 VSS.n29 VSS.n28 2.21603
R451 VSS.n96 VSS.n95 2.0795
R452 VSS.n128 VSS.n127 2.00075
R453 VSS.n130 VSS.n129 2.00075
R454 VSS.n126 VSS.n109 1.3505
R455 VSS.n130 VSS.n126 1.3505
R456 VSS.n139 VSS.n135 1.3005
R457 VSS.n140 VSS.n138 1.3005
R458 VSS.n138 VSS.n137 1.1469
R459 VSS.n43 VSS.n12 0.959
R460 VSS.n91 VSS.n87 0.887054
R461 VSS.n119 VSS.n118 0.743357
R462 VSS.n113 VSS.n112 0.743357
R463 VSS.n116 VSS.n109 0.734
R464 VSS.n117 VSS.n115 0.734
R465 VSS.n129 VSS.n128 0.70025
R466 VSS.n127 VSS.n1 0.63275
R467 VSS.n117 VSS.n116 0.617
R468 VSS.n115 VSS.n114 0.617
R469 VSS.n125 VSS.n124 0.578278
R470 VSS.n132 VSS.n131 0.578278
R471 VSS.n47 VSS.n16 0.5321
R472 VSS.n134 VSS.t18 0.465707
R473 VSS.n122 VSS.n121 0.347167
R474 VSS.t13 VSS.n75 0.217167
R475 VSS.n7 VSS.t15 0.217167
R476 VSS.n8 VSS.t15 0.217167
R477 VSS.n146 VSS.n145 0.202502
R478 VSS.n137 VSS.t10 0.15268
R479 VSS.n89 VSS.n71 0.142605
R480 VSS.n93 VSS.n71 0.142605
R481 VSS.n59 VSS.n49 0.142605
R482 VSS.n31 VSS.n24 0.142605
R483 VSS.n58 VSS.n50 0.142605
R484 VSS.n54 VSS.n50 0.142605
R485 VSS.n92 VSS.n72 0.142605
R486 VSS.n38 VSS.n37 0.142605
R487 VSS.n36 VSS.n34 0.142605
R488 VSS.n45 VSS.n19 0.142605
R489 VSS.n20 VSS.n19 0.142605
R490 VSS.n46 VSS.n18 0.142605
R491 VSS.n27 VSS.n24 0.142605
R492 VSS.n85 VSS.n74 0.142605
R493 VSS.n40 VSS.n34 0.142605
R494 VSS.n66 VSS.n14 0.142605
R495 VSS.n62 VSS.n14 0.142605
R496 VSS.n100 VSS.n99 0.142605
R497 VSS.n30 VSS.n25 0.142605
R498 VSS.n102 VSS.n10 0.142605
R499 VSS.n65 VSS.n15 0.142605
R500 VSS.n98 VSS.n10 0.142605
R501 VSS.n146 VSS.n2 0.135002
R502 VSS.n64 VSS.n60 0.0887667
R503 VSS.n64 VSS.n11 0.0855667
R504 VSS.n83 VSS.n82 0.079578
R505 VSS.n28 VSS.n25 0.0709482
R506 VSS.n18 VSS.n17 0.0709482
R507 VSS.n39 VSS.n38 0.0709482
R508 VSS.n49 VSS.n48 0.0709482
R509 VSS.n63 VSS.n15 0.0709482
R510 VSS.n101 VSS.n100 0.0709482
R511 VSS.n90 VSS.n72 0.0709482
R512 VSS.n74 VSS.n73 0.0709482
R513 VSS.n2 VSS.n1 0.068
R514 VSS.n83 VSS.n69 0.068
R515 VSS.n91 VSS.n11 0.0621
R516 VSS.n67 VSS.n13 0.0545
R517 VSS.n97 VSS.n9 0.0545
R518 VSS.n103 VSS.n9 0.0545
R519 VSS.n56 VSS.n55 0.0545
R520 VSS.n57 VSS.n56 0.0545
R521 VSS.n41 VSS.n33 0.0545
R522 VSS.n35 VSS.n33 0.0545
R523 VSS.n80 VSS.n79 0.0545
R524 VSS.n94 VSS.n70 0.0545
R525 VSS.n88 VSS.n70 0.0545
R526 VSS.n22 VSS.n21 0.0545
R527 VSS.n44 VSS.n22 0.0545
R528 VSS.n84 VSS.n80 0.0545
R529 VSS.n61 VSS.n13 0.0545
R530 VSS.n77 VSS.t13 0.0514603
R531 VSS.n52 VSS.n51 0.0477727
R532 VSS.n76 VSS.n6 0.0477727
R533 VSS.n105 VSS.n104 0.0477727
R534 VSS.n26 VSS.n23 0.0458782
R535 VSS.n32 VSS.n23 0.0458782
R536 VSS.n143 VSS.n142 0.041125
R537 VSS.n136 VSS.n3 0.041125
R538 VSS.n142 VSS.n141 0.041125
R539 VSS.n29 VSS.n16 0.0319
R540 VSS.n60 VSS.n47 0.0289
R541 VSS.n82 VSS.n81 0.0123666
R542 VSS.n87 VSS.n86 0.00877641
R543 VSS VSS.n0 0.006125
R544 VX.n0 VX.t1 13.142
R545 VX.n1 VX.t2 13.142
R546 VX.n0 VX.t0 13.0779
R547 VX.n1 VX.n0 1.3505
R548 VX VX.n1 0.068
R549 GP.n0 GP.t2 48.6459
R550 GP.n3 GP.n2 12.771
R551 GP.n0 GP.t1 12.6241
R552 GP.n3 GP.n0 1.36738
R553 GP.n2 GP.t0 0.6557
R554 GP.n2 GP.n1 0.4541
R555 GP GP.n3 0.068
R556 GB.n0 GB.t3 62.0963
R557 GB.n0 GB.t2 50.1597
R558 GB.n1 GB.t4 47.4597
R559 GB.n5 GB.n4 13.0552
R560 GB.n2 GB.t0 12.9083
R561 GB.n2 GB.n1 1.47087
R562 GB.n5 GB.n2 1.36738
R563 GB.n1 GB.n0 1.3505
R564 GB.n4 GB.t1 0.6557
R565 GB.n4 GB.n3 0.4541
R566 GB GB.n5 0.068
R567 DI.n0 DI.t1 51.0678
R568 DI.n0 DI.t2 44.4281
R569 DI.n2 DI.t0 13.0005
R570 DI.t0 DI.n1 5.98411
R571 DI.n2 DI.n0 2.0255
R572 DI DI.n2 0.068
R573 IN1.n0 IN1.t3 72.6175
R574 IN1.n0 IN1.t1 67.6675
R575 IN1.n4 IN1.n3 39.5775
R576 IN1.n1 IN1.t2 33.7243
R577 IN1.n4 IN1.n1 9.9005
R578 IN1.n1 IN1.n0 1.184
R579 IN1 IN1.n4 0.068
R580 IN1.n3 IN1.t0 0.0187
R581 IN1.n3 IN1.n2 0.0131
R582 ITAIL.n0 ITAIL.t0 45.0194
R583 ITAIL.n0 ITAIL.t1 40.0694
R584 ITAIL.n3 ITAIL.n2 30.6769
R585 ITAIL.n3 ITAIL.n0 5.7425
R586 ITAIL.n2 ITAIL.t2 0.0915
R587 ITAIL ITAIL.n3 0.068
R588 ITAIL.n2 ITAIL.n1 0.0635
C0 BIAS VSS 2.0525655445165482e-14
C1 BIAS.n0 VSS 2.1418244240883207e-15
C2 BIAS.n1 VSS 1.8360726941235513e-17
C3 BIAS.n10 VSS 5.2151768774312887e-16
C4 BIAS.n11 VSS 4.5913616738413201e-16
C5 BIAS.n12 VSS 7.2947207384682022e-18
C6 BIAS.n13 VSS 1.5429179122131495e-17
C7 BIAS.n14 VSS 5.8630956382080368e-18
C8 BIAS.n15 VSS 1.0904398792644857e-15
C9 BIAS.n16 VSS 4.7143781531380301e-18
C10 BIAS.n17 VSS 2.6743843173489529e-17
C11 BIAS.n18 VSS 4.7882031843121957e-18
C12 BIAS.n19 VSS 4.2875811353072175e-16
C13 BIAS.n2 VSS 5.8630956382080368e-18
C14 BIAS.n20 VSS 2.7516671363080272e-16
C15 BIAS.n21 VSS 1.7560211210038591e-18
C16 BIAS.n22 VSS 1.4502845346352281e-15
C17 BIAS.n23 VSS 2.6939195563673477e-16
C18 BIAS.n24 VSS 3.2401995477292703e-16
C19 BIAS.n25 VSS 2.3882031614602335e-14
C20 BIAS.n3 VSS 5.8630956382080368e-18
C21 BIAS.n4 VSS 3.8398859548055642e-16
C22 BIAS.n5 VSS 4.8620029761594641e-18
C23 BIAS.n6 VSS 4.7143781531380301e-18
C24 BIAS.n7 VSS 4.6631423195368154e-15
C25 BIAS.n8 VSS 4.7882031843121957e-18
C26 BIAS.n9 VSS 4.7882031843121957e-18
C27 BIAS.t0 VSS 3.2358079048491667e-16
C28 BIAS.t1 VSS 1.218191256287102e-16
C29 BIAS.t2 VSS 9.2463769301172519e-17
C30 BIAS.t3 VSS 2.4512080931935904e-15
C31 BIAS.t4 VSS 1.211071242169416e-16
C32 BIAS.t5 VSS 1.6573454485667598e-16
C33 DATA VSS 5.1379399999999998e-16
C34 DI VSS 2.2179081460834401e-17
C35 DI.n0 VSS 1.0017037620543691e-15
C36 DI.n1 VSS 2.4159379427858677e-17
C37 DI.n2 VSS 3.233882360543154e-16
C38 DI.t0 VSS 1.1136933376781814e-16
C39 DI.t1 VSS 4.2534900112241549e-16
C40 DI.t2 VSS 4.4643120611238895e-16
C41 DISABLE VSS 5.2433935257749008e-15
C42 DISABLE.t0 VSS 2.0364364742250994e-15
C43 DUMMY VSS 3.5341178074259183e-16
C44 DUMMY.t0 VSS 3.981542192574083e-16
C45 GB VSS 1.3680840692452363e-17
C46 GB.n0 VSS 1.6370626537839774e-15
C47 GB.n1 VSS 7.546302885818571e-16
C48 GB.n2 VSS 5.0442576867905278e-16
C49 GB.n3 VSS 2.1987007786293946e-17
C50 GB.n4 VSS 3.1345590107860386e-16
C51 GB.n5 VSS 3.7848174079287258e-16
C52 GB.t0 VSS 4.5674122831800634e-16
C53 GB.t1 VSS 3.1759141601949915e-17
C54 GB.t2 VSS 3.8270671190802128e-16
C55 GB.t3 VSS 3.2867224966964272e-16
C56 GB.t4 VSS 3.4159646710727039e-16
C57 GP VSS 1.2859617104615066e-17
C58 GP.n0 VSS 1.0167393392011568e-15
C59 GP.n1 VSS 2.0667298396768527e-17
C60 GP.n2 VSS 2.7518348218178656e-16
C61 GP.n3 VSS 3.3333496476805066e-16
C62 GP.t0 VSS 2.9852693888583838e-17
C63 GP.t1 VSS 4.0955474366671917e-16
C64 GP.t2 VSS 3.3197786079231928e-16
C65 ICTRL VSS 1.4512356912415831e-18
C66 ICTRL.n0 VSS 3.6379660053652396e-15
C67 ICTRL.n1 VSS 1.8475561644452366e-15
C68 ICTRL.n2 VSS 3.5722957864940048e-16
C69 ICTRL.n3 VSS 2.549901484004264e-16
C70 ICTRL.t0 VSS 1.1391117870714203e-14
C71 ICTRL.t1 VSS 1.1211990390893192e-15
C72 ICTRL.t2 VSS 3.7964527949815344e-16
C73 ICTRL.t3 VSS 1.1478426807432574e-14
C74 ICTRL.t4 VSS 1.1391117870714203e-14
C75 IN1 VSS 4.6463123249041189e-18
C76 IN1.n0 VSS 4.8898279896207374e-15
C77 IN1.n1 VSS 9.8850394121049372e-16
C78 IN1.n2 VSS 2.9869106963959783e-16
C79 IN1.n3 VSS 2.3100546037030706e-15
C80 IN1.n4 VSS 1.1108531279714808e-15
C81 IN1.t0 VSS 4.3144197642838152e-16
C82 IN1.t1 VSS 1.6485125508864135e-14
C83 IN1.t2 VSS 1.76837601000304e-15
C84 IN1.t3 VSS 1.6656679460234165e-14
C85 IN2 VSS 1.125087316455548e-17
C86 IN2.n0 VSS 7.3406732431676887e-15
C87 IN2.n1 VSS 3.285842983515027e-15
C88 IN2.t0 VSS 5.138382525233704e-15
C89 IN2.t1 VSS 8.7279132414088674e-15
C90 IN2.t2 VSS 2.4629371335101572e-15
C91 IPB VSS 5.9339188418636484e-18
C92 IPB.n0 VSS 3.9560695707855371e-15
C93 IPB.n1 VSS 9.6852617717797779e-16
C94 IPB.t0 VSS 4.5558373500737932e-15
C95 IPB.t1 VSS 1.5904142195602276e-15
C96 IPB.t2 VSS 4.6766187635606034e-15
C97 ITAIL VSS 9.8690289898303628e-18
C98 ITAIL.n0 VSS 4.2931066052461387e-15
C99 ITAIL.n1 VSS 1.2688792744312622e-16
C100 ITAIL.n2 VSS 1.8557866078821455e-15
C101 ITAIL.n3 VSS 1.594204695758468e-15
C102 ITAIL.t0 VSS 6.7114332856208577e-15
C103 ITAIL.t1 VSS 6.4818297997335227e-15
C104 ITAIL.t2 VSS 1.8328204932591105e-16
C105 OUT VSS 1.6466359315051374e-17
C106 OUT.n0 VSS 1.9087204877710837e-15
C107 OUT.t0 VSS 6.3552119310534405e-16
C108 OUT.t1 VSS 7.9796195980852146e-16
C109 SENSE VSS 1.8809459227041961e-18
C110 SENSE.n0 VSS 3.116802934529489e-15
C111 SENSE.t0 VSS 1.7352135945040988e-15
C112 SENSE.t1 VSS 1.4809802525043708e-14
C113 VDD VSS 1.1741043787814261e-17
C114 VDD.n0 VSS 2.937022934303338e-15
C115 VDD.n1 VSS 5.8684221162364178e-16
C116 VDD.n2 VSS 2.3584246324042782e-15
C117 VDD.t0 VSS 1.4208039098418585e-15
C118 VDD.t1 VSS 5.4204999780447369e-16
C119 VDD.t2 VSS 1.4208039098418585e-15
C120 VDD.t3 VSS 5.6203136039273769e-16
C121 VIN VSS 2.0904508739436419e-17
C122 VIN.n0 VSS 5.3049282547384014e-15
C123 VIN.n1 VSS 1.1204113917209899e-15
C124 VIN.n10 VSS 3.0253590330631971e-15
C125 VIN.n100 VSS 1.7376887835414598e-17
C126 VIN.n101 VSS 1.7376887835414598e-17
C127 VIN.n102 VSS 4.1995681205630827e-15
C128 VIN.n103 VSS 1.7109059850676681e-17
C129 VIN.n104 VSS 2.1277836192952404e-17
C130 VIN.n105 VSS 2.1277836192952404e-17
C131 VIN.n106 VSS 1.7644715820152515e-17
C132 VIN.n107 VSS 1.1599174261294168e-14
C133 VIN.n108 VSS 5.5994265051834172e-17
C134 VIN.n109 VSS 1.3323176247086152e-15
C135 VIN.n11 VSS 5.5994265051834172e-17
C136 VIN.n110 VSS 1.7376887835414598e-17
C137 VIN.n111 VSS 1.7376887835414598e-17
C138 VIN.n112 VSS 5.0394845579948674e-15
C139 VIN.n113 VSS 3.0253590330631971e-15
C140 VIN.n114 VSS 1.7644715820152515e-17
C141 VIN.n115 VSS 1.7109059850676681e-17
C142 VIN.n116 VSS 9.6644546698627897e-15
C143 VIN.n117 VSS 1.7376887835414598e-17
C144 VIN.n118 VSS 1.7376887835414598e-17
C145 VIN.n119 VSS 1.3323176247086152e-15
C146 VIN.n12 VSS 2.5904480229724938e-15
C147 VIN.n120 VSS 1.1148128865778338e-15
C148 VIN.n121 VSS 1.2617384800960884e-16
C149 VIN.n122 VSS 2.6127787438638513e-17
C150 VIN.n123 VSS 5.5994265051834172e-17
C151 VIN.n124 VSS 2.1277836192952404e-17
C152 VIN.n125 VSS 1.1599455593210909e-14
C153 VIN.n126 VSS 1.7109059850676681e-17
C154 VIN.n127 VSS 9.705669795665422e-17
C155 VIN.n128 VSS 1.7376887835414598e-17
C156 VIN.n129 VSS 1.3323176247086152e-15
C157 VIN.n13 VSS 5.5994265051834172e-17
C158 VIN.n130 VSS 7.9673902150988045e-16
C159 VIN.n131 VSS 6.3728009110079141e-18
C160 VIN.n132 VSS 4.3676709741140548e-15
C161 VIN.n14 VSS 2.1277836192952404e-17
C162 VIN.n15 VSS 2.1277836192952404e-17
C163 VIN.n16 VSS 6.1593684523719667e-15
C164 VIN.n17 VSS 1.7109059850676681e-17
C165 VIN.n18 VSS 2.1277836192952404e-17
C166 VIN.n19 VSS 2.1277836192952404e-17
C167 VIN.n2 VSS 5.5994265051834172e-17
C168 VIN.n20 VSS 1.7644715820152515e-17
C169 VIN.n21 VSS 4.9116121685379305e-15
C170 VIN.n22 VSS 5.5994265051834172e-17
C171 VIN.n23 VSS 2.0951631835490621e-15
C172 VIN.n24 VSS 5.5994265051834172e-17
C173 VIN.n25 VSS 2.1277836192952404e-17
C174 VIN.n26 VSS 2.1277836192952404e-17
C175 VIN.n27 VSS 1.7109059850676681e-17
C176 VIN.n28 VSS 2.1277836192952404e-17
C177 VIN.n29 VSS 2.1277836192952404e-17
C178 VIN.n3 VSS 2.1277836192952404e-17
C179 VIN.n30 VSS 1.7644715820152515e-17
C180 VIN.n31 VSS 4.9116121685379305e-15
C181 VIN.n32 VSS 5.5994265051834172e-17
C182 VIN.n33 VSS 1.473504047125343e-15
C183 VIN.n34 VSS 1.7376887835414598e-17
C184 VIN.n35 VSS 1.7376887835414598e-17
C185 VIN.n36 VSS 4.412346482492607e-15
C186 VIN.n37 VSS 1.7109059850676681e-17
C187 VIN.n38 VSS 2.1277836192952404e-17
C188 VIN.n39 VSS 2.1277836192952404e-17
C189 VIN.n4 VSS 2.1277836192952404e-17
C190 VIN.n40 VSS 1.7644715820152515e-17
C191 VIN.n41 VSS 4.229621402568995e-14
C192 VIN.n42 VSS 5.5994265051834172e-17
C193 VIN.n43 VSS 1.3323176247086152e-15
C194 VIN.n44 VSS 1.7376887835414598e-17
C195 VIN.n45 VSS 1.7376887835414598e-17
C196 VIN.n46 VSS 6.1593684523719667e-15
C197 VIN.n47 VSS 4.9116121685379305e-15
C198 VIN.n48 VSS 1.7644715820152515e-17
C199 VIN.n49 VSS 1.7109059850676681e-17
C200 VIN.n5 VSS 8.4663323694398756e-15
C201 VIN.n50 VSS 6.1593684523719667e-15
C202 VIN.n51 VSS 1.7376887835414598e-17
C203 VIN.n52 VSS 1.7376887835414598e-17
C204 VIN.n53 VSS 1.3323176247086152e-15
C205 VIN.n54 VSS 1.1950698491262686e-15
C206 VIN.n55 VSS 5.5994265051834172e-17
C207 VIN.n56 VSS 2.1277836192952404e-17
C208 VIN.n57 VSS 4.229621402568995e-14
C209 VIN.n58 VSS 1.7644715820152515e-17
C210 VIN.n59 VSS 1.7109059850676681e-17
C211 VIN.n6 VSS 1.7109059850676681e-17
C212 VIN.n60 VSS 2.1277836192952404e-17
C213 VIN.n61 VSS 1.7376887835414598e-17
C214 VIN.n62 VSS 1.7376887835414598e-17
C215 VIN.n63 VSS 1.3323176247086152e-15
C216 VIN.n64 VSS 1.1950698491262686e-15
C217 VIN.n65 VSS 1.1950698491262686e-15
C218 VIN.n66 VSS 1.3323176247086152e-15
C219 VIN.n67 VSS 1.7376887835414598e-17
C220 VIN.n68 VSS 1.7376887835414598e-17
C221 VIN.n69 VSS 6.1593684523719667e-15
C222 VIN.n7 VSS 2.1277836192952404e-17
C223 VIN.n70 VSS 1.7109059850676681e-17
C224 VIN.n71 VSS 2.1277836192952404e-17
C225 VIN.n72 VSS 2.1277836192952404e-17
C226 VIN.n73 VSS 1.7644715820152515e-17
C227 VIN.n74 VSS 4.229621402568995e-14
C228 VIN.n75 VSS 5.5994265051834172e-17
C229 VIN.n76 VSS 1.3323176247086152e-15
C230 VIN.n77 VSS 1.7376887835414598e-17
C231 VIN.n78 VSS 1.7376887835414598e-17
C232 VIN.n79 VSS 2.7090012926873672e-14
C233 VIN.n8 VSS 2.1277836192952404e-17
C234 VIN.n80 VSS 4.229621402568995e-14
C235 VIN.n81 VSS 1.7644715820152515e-17
C236 VIN.n82 VSS 1.7109059850676681e-17
C237 VIN.n83 VSS 2.9676930234291055e-14
C238 VIN.n84 VSS 1.7376887835414598e-17
C239 VIN.n85 VSS 1.7376887835414598e-17
C240 VIN.n86 VSS 1.3323176247086152e-15
C241 VIN.n87 VSS 2.7629115212329595e-15
C242 VIN.n88 VSS 5.5994265051834172e-17
C243 VIN.n89 VSS 2.1277836192952404e-17
C244 VIN.n9 VSS 1.7644715820152515e-17
C245 VIN.n90 VSS 4.229621402568995e-14
C246 VIN.n91 VSS 1.7644715820152515e-17
C247 VIN.n92 VSS 1.7109059850676681e-17
C248 VIN.n93 VSS 2.1277836192952404e-17
C249 VIN.n94 VSS 1.7376887835414598e-17
C250 VIN.n95 VSS 1.7376887835414598e-17
C251 VIN.n96 VSS 1.3323176247086152e-15
C252 VIN.n97 VSS 1.3488669747109345e-15
C253 VIN.n98 VSS 1.0644193069915105e-15
C254 VIN.n99 VSS 1.3323176247086152e-15
C255 VIN.t0 VSS 9.9930503486168767e-14
C256 VIN.t1 VSS 9.8076526154842188e-15
C257 VIN.t10 VSS 1.0434249127046752e-14
C258 VIN.t11 VSS 2.9587818349663184e-15
C259 VIN.t2 VSS 9.9930503486168767e-14
C260 VIN.t3 VSS 9.8076526154842188e-15
C261 VIN.t4 VSS 9.9930503486168767e-14
C262 VIN.t5 VSS 9.8076526154842188e-15
C263 VIN.t6 VSS 9.9930503486168767e-14
C264 VIN.t7 VSS 9.9930503486168767e-14
C265 VIN.t8 VSS 1.0434249127046752e-14
C266 VIN.t9 VSS 2.9587818349663184e-15
C267 VSET VSS 1.267581855794052e-15
C268 VSET.t0 VSS 8.1137181442059468e-15
C269 VX VSS 1.5899840807910551e-17
C270 VX.n0 VSS 8.3708462440838158e-16
C271 VX.n1 VSS 3.9966294513386825e-16
C272 VX.t0 VSS 6.5512379342519835e-16
C273 VX.t1 VSS 3.6168939811232071e-16
C274 VX.t2 VSS 3.6168939811232071e-16
C275 IN1 SENSE 6.9340500000000005e-17
C276 VIN SENSE 1.6116700000000003e-14
C277 VX VDD 2.9333199999999999e-19
C278 IN2 SENSE 6.0057500000000002e-15
C279 ICTRL VIN 4.2531300000000009e-14
C280 VX DUMMY 3.3480599999999999e-16
C281 GB OUT 6.5083600000000007e-17
C282 BIAS OUT 2.1524100000000004e-16
C283 DI GB 1.6138800000000001e-16
C284 IN2 ICTRL 1.1530500000000001e-15
C285 ITAIL VSET 5.608930000000001e-15
C286 VIN IPB 1.2211700000000002e-14
C287 ICTRL SENSE 5.7641700000000007e-15
C288 BIAS VIN 1.4526299999999999e-14
C289 GP OUT 1.7895500000000002e-16
C290 GB VX 2.85847e-16
C291 BIAS VX 4.0741800000000004e-16
C292 DI GP 1.13075e-19
C293 ITAIL IN1 6.9786699999999999e-16
C294 VIN ITAIL 2.3445200000000003e-14
C295 GB VDD 1.7549500000000002e-15
C296 IN2 ITAIL 1.2982000000000001e-16
C297 GB DUMMY 2.0769700000000003e-16
C298 GP VX 1.5857600000000001e-16
C299 BIAS DUMMY 1.2036600000000001e-18
C300 ICTRL BIAS 7.1750700000000001e-15
C301 ITAIL SENSE 5.6079499999999999e-15
C302 VSET IN1 5.6066000000000008e-15
C303 VIN VSET 4.3379399999999996e-15
C304 GP VDD 1.0070900000000002e-15
C305 OUT VX 2.8288800000000001e-16
C306 GP DUMMY 8.2815100000000015e-18
C307 BIAS GB 1.0092300000000001e-16
C308 VIN IN1 1.2538800000000001e-14
C309 IPB ITAIL 1.37509e-15
C310 OUT VDD 6.5634800000000003e-18
C311 IN2 IN1 3.1280100000000005e-15
C312 DI VDD 4.64497e-16
C313 IN2 VIN 1.2069800000000001e-14
C314 OUT DUMMY 2.6675400000000002e-19
C315 GB GP 9.4624600000000007e-16
C316 BIAS DISABLE 1.2698399999999999e-15
.ends nrz_reference_integrated
