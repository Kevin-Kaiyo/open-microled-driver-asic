* NGSPICE file created from nrz_reference_integrated.ext - technology: gf180mcuD

.subckt nrz_reference_integrated DATA OUT VDD VSS BIAS DUMMY VSET SENSE IPB IN2 ICTRL
+ DISABLE
X0 VSS a_n1100_4414# a_642_3750# VSS nfet_06v0 ad=1.1p pd=5.88u as=1.1p ps=5.88u w=2.5u l=0.7u
X1 VSS ICTRL ICTRL VSS pfet_06v0 ad=44p pd=0.20088m as=44p ps=0.20088m w=100u l=10u
X2 VSS ICTRL BIAS VSS pfet_06v0 ad=44p pd=0.20088m as=44p ps=0.20088m w=100u l=10u
X3 a_n1100_4414# DATA VSS ppolyf_u_1k_6p0 r_width=1u r_length=58u
X4 a_5670_3750# a_642_3750# DUMMY VSS nfet_06v0 ad=1.1p pd=5.88u as=1.1p ps=5.88u w=2.5u l=0.7u
X5 VSS IPB IPB VSS pfet_06v0 ad=8.8p pd=40.88u as=8.8p ps=40.88u w=20u l=4u
X6 VSS DISABLE BIAS VSS nfet_06v0 ad=4.4p pd=20.88u as=4.4p ps=20.88u w=10u l=0.7u
X7 a_25912_40000# SENSE IN2 VSS pfet_06v0 ad=44p pd=0.20088m as=44p ps=0.20088m w=100u l=10u
X8 VSS IN2 ICTRL VSS nfet_06v0 ad=8.8p pd=40.88u as=8.8p ps=40.88u w=20u l=1u
X9 a_25912_40000# VSET a_28912_40000# VSS pfet_06v0 ad=44p pd=0.20088m as=44p ps=0.20088m w=100u l=10u
X10 VSS IPB a_25912_40000# VSS pfet_06v0 ad=8.8p pd=40.88u as=8.8p ps=40.88u w=20u l=4u
X11 VSS BIAS OUT VSS nfet_03v3 ad=0.88p pd=4.88u as=0.88p ps=4.88u w=2u l=1u
X12 VSS ICTRL SENSE VSS pfet_06v0 ad=44p pd=0.20088m as=44p ps=0.20088m w=100u l=10u
X13 a_5670_3750# a_3042_3750# OUT VSS nfet_06v0 ad=1.1p pd=5.88u as=1.1p ps=5.88u w=2.5u l=0.7u
X14 VDD a_n1100_4414# a_642_3750# VDD pfet_06v0 ad=1.7292p pd=8.74u as=1.7292p ps=8.74u w=3.93u l=0.55u
X15 VSS a_28912_40000# IN2 VSS nfet_06v0 ad=22p pd=0.10088m as=22p ps=0.10088m w=50u l=10u
X16 VSS BIAS a_5670_3750# VSS nfet_03v3 ad=2.5344p pd=12.4u as=2.5344p ps=12.4u w=5.76u l=1u
X17 VSS BIAS BIAS VSS nfet_03v3 ad=0.88p pd=4.88u as=0.88p ps=4.88u w=2u l=1u
X18 VSS a_642_3750# a_3042_3750# VSS nfet_06v0 ad=1.1p pd=5.88u as=1.1p ps=5.88u w=2.5u l=0.7u
X19 VSS a_28912_40000# a_28912_40000# VSS nfet_06v0 ad=22p pd=0.10088m as=22p ps=0.10088m w=50u l=10u
X20 VDD a_642_3750# a_3042_3750# VDD pfet_06v0 ad=1.7292p pd=8.74u as=1.7292p ps=8.74u w=3.93u l=0.55u
.ends
