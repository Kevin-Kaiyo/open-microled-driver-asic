* NGSPICE file created from nrz_reference_integrated.ext - technology: gf180mcuD

X0 VSS DI GB VSS nfet_06v0 ad=1.1p pd=5.88u as=1.1p ps=5.88u w=2.5u l=0.7u
X1 VIN ICTRL ICTRL VIN pfet_06v0 ad=44p pd=0.20088m as=44p ps=0.20088m w=100u l=10u
X2 VIN ICTRL BIAS VIN pfet_06v0 ad=44p pd=0.20088m as=44p ps=0.20088m w=100u l=10u
X3 DI DATA VSS ppolyf_u_1k_6p0 r_width=1u r_length=58u
X4 VX GB DUMMY VSS nfet_06v0 ad=1.1p pd=5.88u as=1.1p ps=5.88u w=2.5u l=0.7u
X5 VIN IPB IPB VIN pfet_06v0 ad=8.8p pd=40.88u as=8.8p ps=40.88u w=20u l=4u
X6 VSS DISABLE BIAS VSS nfet_06v0 ad=4.4p pd=20.88u as=4.4p ps=20.88u w=10u l=0.7u
X7 ITAIL SENSE IN2 VIN pfet_06v0 ad=44p pd=0.20088m as=44p ps=0.20088m w=100u l=10u
X8 VSS IN2 ICTRL VSS nfet_06v0 ad=8.8p pd=40.88u as=8.8p ps=40.88u w=20u l=1u
X9 ITAIL VSET IN1 VIN pfet_06v0 ad=44p pd=0.20088m as=44p ps=0.20088m w=100u l=10u
X10 VIN IPB ITAIL VIN pfet_06v0 ad=8.8p pd=40.88u as=8.8p ps=40.88u w=20u l=4u
X11 VSS BIAS OUT VSS nfet_03v3 ad=0.88p pd=4.88u as=0.88p ps=4.88u w=2u l=1u
X12 VIN ICTRL SENSE VIN pfet_06v0 ad=44p pd=0.20088m as=44p ps=0.20088m w=100u l=10u
X13 VX GP OUT VSS nfet_06v0 ad=1.1p pd=5.88u as=1.1p ps=5.88u w=2.5u l=0.7u
X14 VDD DI GB VDD pfet_06v0 ad=1.7292p pd=8.74u as=1.7292p ps=8.74u w=3.93u l=0.55u
X15 VSS IN1 IN2 VSS nfet_06v0 ad=22p pd=0.10088m as=22p ps=0.10088m w=50u l=10u
X16 VSS BIAS VX VSS nfet_03v3 ad=2.5344p pd=12.4u as=2.5344p ps=12.4u w=5.76u l=1u
X17 VSS BIAS BIAS VSS nfet_03v3 ad=0.88p pd=4.88u as=0.88p ps=4.88u w=2u l=1u
X18 VSS GB GP VSS nfet_06v0 ad=1.1p pd=5.88u as=1.1p ps=5.88u w=2.5u l=0.7u
X19 VSS IN1 IN1 VSS nfet_06v0 ad=22p pd=0.10088m as=22p ps=0.10088m w=50u l=10u
X20 VDD GB GP VDD pfet_06v0 ad=1.7292p pd=8.74u as=1.7292p ps=8.74u w=3.93u l=0.55u
C0 OUT DUMMY 0
C1 VIN SENSE 16.1167f
C2 ICTRL BIAS 7.17507f
C3 ITAIL SENSE 5.60795f
C4 IN1 VSET 5.6066f
C5 VX OUT 0.28289f
C6 GP DUMMY 0.00828f
C7 VIN VSET 4.33794f
C8 ITAIL VSET 5.60893f
C9 GP VX 0.15858f
C10 DI VDD 0.4645f
C11 VIN BIAS 14.5263f
C12 GP OUT 0.17896f
C13 GB DUMMY 0.2077f
C14 VIN IPB 12.2117f
C15 GB VX 0.28585f
C16 ITAIL IPB 1.37509f
C17 VIN ICTRL 42.5313f
C18 GB OUT 0.06508f
C19 SENSE IN2 6.00575f
C20 BIAS DUMMY 0.0012f
C21 IN1 VIN 12.5388f
C22 GB GP 0.94625f
C23 ITAIL IN1 0.69787f
C24 VX BIAS 0.40742f
C25 BIAS OUT 0.21524f
C26 ITAIL VIN 23.4452f
C27 VX VDD 0
C28 DI GP 0
C29 IN2 ICTRL 1.15305f
C30 VDD OUT 0.00656f
C31 GB BIAS 0.10092f
C32 BIAS DISABLE 1.26984f
C33 GP VDD 1.00709f
C34 IN1 IN2 3.12801f
C35 DI GB 0.16139f
C36 SENSE ICTRL 5.76417f
C37 VIN IN2 12.0698f
C38 IN1 SENSE 0.06934f
C39 GB VDD 1.75495f
C40 ITAIL IN2 0.12982f
C41 VX DUMMY 0.33481f
C42 DUMMY VSS 0.75157f
C43 OUT VSS 3.35867f
C44 DATA VSS 0.51379f
C45 DISABLE VSS 7.27983f
C46 BIAS VSS 59.8071f
C47 ICTRL VSS 41.8607f
C48 IN2 VSS 26.967f
C49 SENSE VSS 19.6637f
C50 VSET VSS 9.3813f
C51 IPB VSS 15.7534f
C52 VDD VSS 9.83972f
C53 VIN VSS 0.96903p
C54 VX VSS 2.63115f ; **FLOATING
C55 GP VSS 2.43017f ; **FLOATING
C56 GB VSS 5.1652f ; **FLOATING
C57 DI VSS 2.35458f ; **FLOATING
C58 IN1 VSS 44.9442f ; **FLOATING
C59 ITAIL VSS 21.2564f ; **FLOATING
