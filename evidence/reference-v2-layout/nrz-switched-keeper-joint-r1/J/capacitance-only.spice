* Explicit control derived from full raw RC; original RC retained.
.subckt nrz_reference_integrated DATA OUT VDD VSS BIAS DUMMY VIN VSET SENSE IPB IN2 ICTRL DISABLE KRET
X0 VSS DI GB VSS nfet_06v0 ad=1.1p pd=5.88u as=1.1p ps=5.88u w=2.5u l=0.7u
X1 VIN ICTRL ICTRL VIN pfet_06v0 ad=44p pd=0.20088m as=44p ps=0.20088m w=100u l=10u
X2 VIN ICTRL BIAS VIN pfet_06v0 ad=44p pd=0.20088m as=44p ps=0.20088m w=100u l=10u
X4 VX GB DUMMY VSS nfet_06v0 ad=1.1p pd=5.88u as=1.1p ps=5.88u w=2.5u l=0.7u
X5 VIN IPB IPB VIN pfet_06v0 ad=8.8p pd=40.88u as=8.8p ps=40.88u w=20u l=4u
X6 VSS DISABLE BIAS VSS nfet_06v0 ad=4.4p pd=20.88u as=4.4p ps=20.88u w=10u l=0.7u
X7 ITAIL SENSE IN2 VIN pfet_06v0 ad=44p pd=0.20088m as=44p ps=0.20088m w=100u l=10u
X8 VSS IN2 ICTRL VSS nfet_06v0 ad=8.8p pd=40.88u as=8.8p ps=40.88u w=20u l=1u
X9 ITAIL VSET IN1 VIN pfet_06v0 ad=44p pd=0.20088m as=44p ps=0.20088m w=100u l=10u
X10 VIN IPB ITAIL VIN pfet_06v0 ad=8.8p pd=40.88u as=8.8p ps=40.88u w=20u l=4u
X11 VSS BIAS OUT VSS nfet_03v3 ad=0.88p pd=4.88u as=0.88p ps=4.88u w=2u l=1u
X12 VIN ICTRL SENSE VIN pfet_06v0 ad=44p pd=0.20088m as=44p ps=0.20088m w=100u l=10u
X13 VSS DISABLE KRET VSS nfet_06v0 ad=0.44p pd=2.88u as=0.44p ps=2.88u w=1u l=0.7u
X14 VX GP OUT VSS nfet_06v0 ad=1.1p pd=5.88u as=1.1p ps=5.88u w=2.5u l=0.7u
X15 VDD DI GB VDD pfet_06v0 ad=1.7292p pd=8.74u as=1.7292p ps=8.74u w=3.93u l=0.55u
X16 VSS IN1 IN2 VSS nfet_06v0 ad=22p pd=0.10088m as=22p ps=0.10088m w=50u l=10u
X17 VSS BIAS VX VSS nfet_03v3 ad=2.5344p pd=12.4u as=2.5344p ps=12.4u w=5.76u l=1u
X18 VSS BIAS BIAS VSS nfet_03v3 ad=0.88p pd=4.88u as=0.88p ps=4.88u w=2u l=1u
X19 VSS GB GP VSS nfet_06v0 ad=1.1p pd=5.88u as=1.1p ps=5.88u w=2.5u l=0.7u
X20 VSS IN1 IN1 VSS nfet_06v0 ad=22p pd=0.10088m as=22p ps=0.10088m w=50u l=10u
X21 VDD GB GP VDD pfet_06v0 ad=1.7292p pd=8.74u as=1.7292p ps=8.74u w=3.93u l=0.55u
X3 DI DATA VSS ppolyf_u_1k_6p0 r_width=1u r_length=58u
C0 BIAS VSS 2.05256563374e-14
C1 BIAS VSS 2.14182451719e-15
C2 BIAS VSS 1.83607277393e-17
C3 BIAS VSS 5.21517710412e-16
C4 BIAS VSS 4.59136187342e-16
C5 BIAS VSS 7.29472105555e-18
C6 BIAS VSS 1.54291797928e-17
C7 BIAS VSS 5.86309589306e-18
C8 BIAS VSS 1.09043992666e-15
C9 BIAS VSS 4.71437835806e-18
C10 BIAS VSS 2.6743844336e-17
C11 BIAS VSS 4.78817815311e-18
C12 BIAS VSS 4.28758132168e-16
C13 BIAS VSS 5.86309589306e-18
C14 BIAS VSS 2.75166725592e-16
C15 BIAS VSS 1.75602119733e-18
C16 BIAS VSS 1.45028207374e-15
C17 BIAS VSS 2.69391967346e-16
C18 BIAS VSS 3.24019968857e-16
C19 BIAS VSS 2.38820326527e-14
C20 BIAS VSS 5.86309589306e-18
C21 BIAS VSS 3.83988612171e-16
C22 BIAS VSS 4.8620031875e-18
C23 BIAS VSS 4.71437835806e-18
C24 BIAS VSS 4.66314252223e-15
C25 BIAS VSS 4.78817815311e-18
C26 BIAS VSS 4.78817815311e-18
C27 BIAS VSS 3.2358080455e-16
C28 BIAS VSS 1.21819130924e-16
C29 BIAS VSS 9.24637733203e-17
C30 BIAS VSS 2.45120819974e-15
C31 BIAS VSS 1.21107129481e-16
C32 BIAS VSS 1.65734552061e-16
C33 DATA VSS 5.13794e-16
C34 DI VSS 2.21790814608e-17
C35 DI VSS 1.00170376205e-15
C36 DI VSS 2.41593794279e-17
C37 DI VSS 3.23388236054e-16
C38 DI VSS 1.11369333768e-16
C39 DI VSS 4.25349001122e-16
C40 DI VSS 4.46431206112e-16
C41 DISABLE VSS 2.08896830815e-17
C42 DISABLE VSS 1.07418476772e-14
C43 DISABLE VSS 2.13234143121e-15
C44 DISABLE VSS 2.17402120852e-15
C45 DUMMY VSS 3.53411780743e-16
C46 DUMMY VSS 3.98154219257e-16
C47 GB VSS 1.36808406925e-17
C48 GB VSS 1.63706265378e-15
C49 GB VSS 7.54630288582e-16
C50 GB VSS 5.04425768679e-16
C51 GB VSS 2.19870077863e-17
C52 GB VSS 3.13455901079e-16
C53 GB VSS 3.78481740793e-16
C54 GB VSS 4.56741228318e-16
C55 GB VSS 3.17591416019e-17
C56 GB VSS 3.82706711908e-16
C57 GB VSS 3.2867224967e-16
C58 GB VSS 3.41596467107e-16
C59 GP VSS 1.28596171046e-17
C60 GP VSS 1.0167393392e-15
C61 GP VSS 2.06672983968e-17
C62 GP VSS 2.75183482182e-16
C63 GP VSS 3.33334964768e-16
C64 GP VSS 2.98526938886e-17
C65 GP VSS 4.09554743667e-16
C66 GP VSS 3.31977860792e-16
C67 ICTRL VSS 1.45123569124e-18
C68 ICTRL VSS 3.63796600537e-15
C69 ICTRL VSS 1.84755616445e-15
C70 ICTRL VSS 3.57229578649e-16
C71 ICTRL VSS 2.549901484e-16
C72 ICTRL VSS 1.13911178707e-14
C73 ICTRL VSS 1.12119903909e-15
C74 ICTRL VSS 3.79645279498e-16
C75 ICTRL VSS 1.14784268074e-14
C76 ICTRL VSS 1.13911178707e-14
C77 IN1 VSS 4.6547264064e-18
C78 IN1 VSS 4.88407048269e-15
C79 IN1 VSS 9.77673725519e-16
C80 IN1 VSS 2.99233146315e-16
C81 IN1 VSS 2.30160518172e-15
C82 IN1 VSS 1.10023666414e-15
C83 IN1 VSS 4.32224741775e-16
C84 IN1 VSS 1.64967325696e-14
C85 IN1 VSS 1.7589345682e-15
C86 IN1 VSS 1.66692341937e-14
C87 IN2 VSS 1.14422537721e-17
C88 IN2 VSS 7.46553337278e-15
C89 IN2 VSS 3.34173110249e-15
C90 IN2 VSS 5.22579095869e-15
C91 IN2 VSS 8.8763706225e-15
C92 IN2 VSS 2.50483168976e-15
C93 IPB VSS 5.94815299043e-18
C94 IPB VSS 3.96555948178e-15
C95 IPB VSS 9.70849618323e-16
C96 IPB VSS 4.56677535012e-15
C97 IPB VSS 1.59422945113e-15
C98 IPB VSS 4.68783794565e-15
C99 ITAIL VSS 9.80714680626e-18
C100 ITAIL VSS 4.21353581654e-15
C101 ITAIL VSS 1.26092457308e-16
C102 ITAIL VSS 1.81754380084e-15
C103 ITAIL VSS 1.55757885517e-15
C104 ITAIL VSS 6.64220008803e-15
C105 ITAIL VSS 6.41450853909e-15
C106 ITAIL VSS 1.82133296201e-16
C107 KRET VSS 2.76755673641e-15
C108 KRET VSS 2.13039326359e-15
C109 OUT VSS 1.64663593151e-17
C110 OUT VSS 1.90872048777e-15
C111 OUT VSS 6.35521193105e-16
C112 OUT VSS 7.97961959809e-16
C113 SENSE VSS 1.88106422361e-18
C114 SENSE VSS 3.11700983628e-15
C115 SENSE VSS 1.73532763869e-15
C116 SENSE VSS 1.48107814608e-14
C117 VDD VSS 1.17410437878e-17
C118 VDD VSS 2.9370229343e-15
C119 VDD VSS 5.86842211624e-16
C120 VDD VSS 2.3584246324e-15
C121 VDD VSS 1.42080390984e-15
C122 VDD VSS 5.42049997804e-16
C123 VDD VSS 1.42080390984e-15
C124 VDD VSS 5.62031360393e-16
C125 VIN VSS 2.09061773162e-17
C126 VIN VSS 5.3053434912e-15
C127 VIN VSS 1.12050529804e-15
C128 VIN VSS 3.0255965119e-15
C129 VIN VSS 1.73782462607e-17
C130 VIN VSS 1.73782462607e-17
C131 VIN VSS 4.19989647838e-15
C132 VIN VSS 1.71103635887e-17
C133 VIN VSS 2.12794679848e-17
C134 VIN VSS 2.12794679848e-17
C135 VIN VSS 1.76461289328e-17
C136 VIN VSS 1.16000866869e-14
C137 VIN VSS 5.59986666223e-17
C138 VIN VSS 1.33242603442e-15
C139 VIN VSS 5.59986666223e-17
C140 VIN VSS 1.73782462607e-17
C141 VIN VSS 1.73782462607e-17
C142 VIN VSS 5.03988140333e-15
C143 VIN VSS 3.0255965119e-15
C144 VIN VSS 1.76461289328e-17
C145 VIN VSS 1.71103635887e-17
C146 VIN VSS 9.6652377683e-15
C147 VIN VSS 1.73782462607e-17
C148 VIN VSS 1.73782462607e-17
C149 VIN VSS 1.33242603442e-15
C150 VIN VSS 2.59065131294e-15
C151 VIN VSS 1.11490417886e-15
C152 VIN VSS 1.26183504503e-16
C153 VIN VSS 2.61298542382e-17
C154 VIN VSS 5.59986666223e-17
C155 VIN VSS 2.12794679848e-17
C156 VIN VSS 1.16003681502e-14
C157 VIN VSS 1.71103635887e-17
C158 VIN VSS 9.70640177228e-17
C159 VIN VSS 1.73782462607e-17
C160 VIN VSS 1.33242603442e-15
C161 VIN VSS 5.59986666223e-17
C162 VIN VSS 7.96801421965e-16
C163 VIN VSS 6.37329959579e-18
C164 VIN VSS 4.36801449258e-15
C165 VIN VSS 2.12794679848e-17
C166 VIN VSS 2.12794679848e-17
C167 VIN VSS 6.15985192114e-15
C168 VIN VSS 1.71103635887e-17
C169 VIN VSS 2.12794679848e-17
C170 VIN VSS 2.12794679848e-17
C171 VIN VSS 5.59986666223e-17
C172 VIN VSS 1.76461289328e-17
C173 VIN VSS 4.9119985643e-15
C174 VIN VSS 5.59986666223e-17
C175 VIN VSS 2.09533224148e-15
C176 VIN VSS 5.59986666223e-17
C177 VIN VSS 2.12794679848e-17
C178 VIN VSS 2.12794679848e-17
C179 VIN VSS 1.71103635887e-17
C180 VIN VSS 2.12794679848e-17
C181 VIN VSS 2.12794679848e-17
C182 VIN VSS 2.12794679848e-17
C183 VIN VSS 1.76461289328e-17
C184 VIN VSS 4.9119985643e-15
C185 VIN VSS 5.59986666223e-17
C186 VIN VSS 1.47362208635e-15
C187 VIN VSS 1.73782462607e-17
C188 VIN VSS 1.73782462607e-17
C189 VIN VSS 4.41268975091e-15
C190 VIN VSS 1.71103635887e-17
C191 VIN VSS 2.12794679848e-17
C192 VIN VSS 2.12794679848e-17
C193 VIN VSS 2.12794679848e-17
C194 VIN VSS 1.76461289328e-17
C195 VIN VSS 4.22995675616e-14
C196 VIN VSS 5.59986666223e-17
C197 VIN VSS 1.33242603442e-15
C198 VIN VSS 1.73782462607e-17
C199 VIN VSS 1.73782462607e-17
C200 VIN VSS 6.15985192114e-15
C201 VIN VSS 4.9119985643e-15
C202 VIN VSS 1.76461289328e-17
C203 VIN VSS 1.71103635887e-17
C204 VIN VSS 8.46697824052e-15
C205 VIN VSS 6.15985192114e-15
C206 VIN VSS 1.73782462607e-17
C207 VIN VSS 1.73782462607e-17
C208 VIN VSS 1.33242603442e-15
C209 VIN VSS 1.19516343175e-15
C210 VIN VSS 5.59986666223e-17
C211 VIN VSS 2.12794679848e-17
C212 VIN VSS 4.22995675616e-14
C213 VIN VSS 1.76461289328e-17
C214 VIN VSS 1.71103635887e-17
C215 VIN VSS 1.71103635887e-17
C216 VIN VSS 2.12794679848e-17
C217 VIN VSS 1.73782462607e-17
C218 VIN VSS 1.73782462607e-17
C219 VIN VSS 1.33242603442e-15
C220 VIN VSS 1.19516343175e-15
C221 VIN VSS 1.19516343175e-15
C222 VIN VSS 1.33242603442e-15
C223 VIN VSS 1.73782462607e-17
C224 VIN VSS 1.73782462607e-17
C225 VIN VSS 6.15985192114e-15
C226 VIN VSS 2.12794679848e-17
C227 VIN VSS 1.71103635887e-17
C228 VIN VSS 2.12794679848e-17
C229 VIN VSS 2.12794679848e-17
C230 VIN VSS 1.76461289328e-17
C231 VIN VSS 4.22995675616e-14
C232 VIN VSS 5.59986666223e-17
C233 VIN VSS 1.33242603442e-15
C234 VIN VSS 1.73782462607e-17
C235 VIN VSS 1.73782462607e-17
C236 VIN VSS 2.70921771756e-14
C237 VIN VSS 2.12794679848e-17
C238 VIN VSS 4.22995675616e-14
C239 VIN VSS 1.76461289328e-17
C240 VIN VSS 1.71103635887e-17
C241 VIN VSS 2.96792468684e-14
C242 VIN VSS 1.73782462607e-17
C243 VIN VSS 1.73782462607e-17
C244 VIN VSS 1.33242603442e-15
C245 VIN VSS 2.7631320079e-15
C246 VIN VSS 5.59986666223e-17
C247 VIN VSS 2.12794679848e-17
C248 VIN VSS 1.76461289328e-17
C249 VIN VSS 4.22995675616e-14
C250 VIN VSS 1.76461289328e-17
C251 VIN VSS 1.71103635887e-17
C252 VIN VSS 2.12794679848e-17
C253 VIN VSS 1.73782462607e-17
C254 VIN VSS 1.73782462607e-17
C255 VIN VSS 1.33242603442e-15
C256 VIN VSS 1.34897607499e-15
C257 VIN VSS 1.06450114288e-15
C258 VIN VSS 1.33242603442e-15
C259 VIN VSS 9.99384614194e-14
C260 VIN VSS 9.80843220949e-15
C261 VIN VSS 1.04351101914e-14
C262 VIN VSS 2.9590093376e-15
C263 VIN VSS 9.99384614194e-14
C264 VIN VSS 9.80843220949e-15
C265 VIN VSS 9.99384614194e-14
C266 VIN VSS 9.80843220949e-15
C267 VIN VSS 9.99384614194e-14
C268 VIN VSS 9.99384614194e-14
C269 VIN VSS 1.04351101914e-14
C270 VIN VSS 2.9590093376e-15
C271 VSET VSS 1.2679285546e-15
C272 VSET VSS 8.1159714454e-15
C273 VX VSS 1.58998408079e-17
C274 VX VSS 8.37084624408e-16
C275 VX VSS 3.99662945134e-16
C276 VX VSS 6.55123793425e-16
C277 VX VSS 3.61689398112e-16
C278 VX VSS 3.61689398112e-16
C279 VX DUMMY 3.34806e-16
C280 GB OUT 6.50836e-17
C281 ITAIL VSET 5.60671e-15
C282 GP VDD 1.00709e-15
C283 BIAS VX 4.07418e-16
C284 DI GB 1.61388e-16
C285 VIN IPB 1.22128e-14
C286 IN2 IN1 2.95668e-15
C287 IN2 VIN 1.20698e-14
C288 ICTRL BIAS 7.17507e-15
C289 GP OUT 1.78955e-16
C290 GB VX 2.85847e-16
C291 ITAIL IN1 6.97867e-16
C292 OUT VDD 6.56348e-18
C293 BIAS DUMMY 1.20366e-18
C294 DI GP 1.13075e-19
C295 VIN ITAIL 2.34124e-14
C296 IN2 SENSE 6.00612e-15
C297 DI VDD 4.64497e-16
C298 ICTRL VIN 4.25313e-14
C299 GB DUMMY 2.07697e-16
C300 GP VX 1.58576e-16
C301 ITAIL SENSE 5.60611e-15
C302 VSET IN1 5.60438e-15
C303 VX VDD 2.93332e-19
C304 VIN VSET 4.33839e-15
C305 ICTRL SENSE 5.76417e-15
C306 BIAS GB 1.00923e-16
C307 BIAS VIN 1.45263e-14
C308 BIAS DISABLE 1.26984e-15
C309 OUT VX 2.82888e-16
C310 GP DUMMY 8.28151e-18
C311 VIN IN1 1.25166e-14
C312 IPB ITAIL 1.35408e-15
C313 IN2 ITAIL 1.13766e-16
C314 IN2 ICTRL 1.15305e-15
C315 OUT DUMMY 2.66754e-19
C316 IN1 SENSE 6.93405e-17
C317 GB GP 9.46246e-16
C318 VIN SENSE 1.61167e-14
C319 GB VDD 1.75495e-15
C320 BIAS OUT 2.15241e-16
C321 DISABLE KRET 5.27759e-16
.ends nrz_reference_integrated
