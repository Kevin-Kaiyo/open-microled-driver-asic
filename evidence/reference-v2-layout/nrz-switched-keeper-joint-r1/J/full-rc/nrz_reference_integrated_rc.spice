* Audited RC model assembly from build/reference-v2-layout/nrz-switched-keeper-joint-r1/J/readback/nrz_reference_integrated.ext.
* Original Magic RC preserved in ../unmodified-full-rc/.
* R/MOS unchanged; C counted once with post-simplification allocation weights.
* Coupling remains at original logical nodes; no EM claim.
.subckt nrz_reference_integrated DATA OUT VDD VSS BIAS DUMMY VIN VSET SENSE IPB IN2 ICTRL DISABLE KRET
X0 VSS.t14 DI.t2 GB.t1 VSS.t13 nfet_06v0 ad=1.1p pd=5.88u as=1.1p ps=5.88u w=2.5u l=0.7u
X1 VIN.t3 ICTRL.t0 ICTRL.t1 VIN.t2 pfet_06v0 ad=44p pd=0.20088m as=44p ps=0.20088m w=100u l=10u
X2 VIN.t1 ICTRL.t3 BIAS.t3 VIN.t0 pfet_06v0 ad=44p pd=0.20088m as=44p ps=0.20088m w=100u l=10u
X3 DI.t0 DATA.t0 VSS.t12 ppolyf_u_1k_6p0 r_width=1u r_length=58u
X4 VX.t1 GB.t2 DUMMY.t0 VSS.t19 nfet_06v0 ad=1.1p pd=5.88u as=1.1p ps=5.88u w=2.5u l=0.7u
X5 VIN.t11 IPB.t0 IPB.t1 VIN.t10 pfet_06v0 ad=8.8p pd=40.88u as=8.8p ps=40.88u w=20u l=4u
X6 VSS.t1 DISABLE.t1 BIAS.t0 VSS.t0 nfet_06v0 ad=4.4p pd=20.88u as=4.4p ps=20.88u w=10u l=0.7u
X7 ITAIL.t0 SENSE.t1 IN2.t1 VIN.t6 pfet_06v0 ad=44p pd=0.20088m as=44p ps=0.20088m w=100u l=10u
X8 VSS.t11 IN2.t2 ICTRL.t2 VSS.t10 nfet_06v0 ad=8.8p pd=40.88u as=8.8p ps=40.88u w=20u l=1u
X9 ITAIL.t1 VSET.t0 IN1.t0 VIN.t7 pfet_06v0 ad=44p pd=0.20088m as=44p ps=0.20088m w=100u l=10u
X10 VIN.t9 IPB.t2 ITAIL.t2 VIN.t8 pfet_06v0 ad=8.8p pd=40.88u as=8.8p ps=40.88u w=20u l=4u
X11 VSS.t5 BIAS.t4 OUT.t1 VSS.t4 nfet_03v3 ad=0.88p pd=4.88u as=0.88p ps=4.88u w=2u l=1u
X12 VIN.t5 ICTRL.t4 SENSE.t0 VIN.t4 pfet_06v0 ad=44p pd=0.20088m as=44p ps=0.20088m w=100u l=10u
X13 VSS.t3 DISABLE.t0 KRET.t0 VSS.t2 nfet_06v0 ad=0.44p pd=2.88u as=0.44p ps=2.88u w=1u l=0.7u
X14 VX.t2 GP.t2 OUT.t0 VSS.t22 nfet_06v0 ad=1.1p pd=5.88u as=1.1p ps=5.88u w=2.5u l=0.7u
X15 VDD.t1 DI.t1 GB.t0 VDD.t0 pfet_06v0 ad=1.7292p pd=8.74u as=1.7292p ps=8.74u w=3.93u l=0.55u
X16 VSS.t18 IN1.t3 IN2.t0 VSS.t17 nfet_06v0 ad=22p pd=0.10088m as=22p ps=0.10088m w=50u l=10u
X17 VSS.t7 BIAS.t5 VX.t0 VSS.t6 nfet_03v3 ad=2.5344p pd=12.4u as=2.5344p ps=12.4u w=5.76u l=1u
X18 VSS.t9 BIAS.t1 BIAS.t2 VSS.t8 nfet_03v3 ad=0.88p pd=4.88u as=0.88p ps=4.88u w=2u l=1u
X19 VSS.t21 GB.t4 GP.t0 VSS.t20 nfet_06v0 ad=1.1p pd=5.88u as=1.1p ps=5.88u w=2.5u l=0.7u
X20 VSS.t16 IN1.t1 IN1.t2 VSS.t15 nfet_06v0 ad=22p pd=0.10088m as=22p ps=0.10088m w=50u l=10u
X21 VDD.t3 GB.t3 GP.t1 VDD.t2 pfet_06v0 ad=1.7292p pd=8.74u as=1.7292p ps=8.74u w=3.93u l=0.55u
R0 DUMMY DUMMY.t0 14.0846
R1 OUT.n0 OUT.t1 19.6265
R2 OUT.n0 OUT.t0 15.1315
R3 OUT OUT.n0 0.0905
R4 DATA DATA.t0 16.4663
R5 KRET KRET.t0 33.1811
R6 DISABLE.n0 DISABLE.t1 105.502
R7 DISABLE.n0 DISABLE.t0 60.4922
R8 DISABLE DISABLE.n0 0.0905
R9 BIAS.n25 BIAS.t5 42.1745
R10 BIAS.n23 BIAS.t1 36.8399
R11 BIAS.n24 BIAS.t4 36.6689
R12 BIAS.n11 BIAS.n10 27.0723
R13 BIAS.n20 BIAS.n19 21.1463
R14 BIAS.n23 BIAS.t2 14.7577
R15 BIAS BIAS.n25 9.50549
R16 BIAS.n15 BIAS.t3 7.79795
R17 BIAS.n4 BIAS.t0 4.70498
R18 BIAS.n6 BIAS.n5 4.57095
R19 BIAS.n16 BIAS.n15 4.57095
R20 BIAS.n9 BIAS.n8 4.5005
R21 BIAS.n18 BIAS.n17 4.5005
R22 BIAS.n5 BIAS.n4 4.5005
R23 BIAS.n19 BIAS.n18 4.5005
R24 BIAS.n14 BIAS.n13 4.5005
R25 BIAS.n2 BIAS.n1 4.5005
R26 BIAS.n10 BIAS.n9 4.5005
R27 BIAS.n3 BIAS.n2 4.5005
R28 BIAS.n22 BIAS.n11 4.5005
R29 BIAS.n8 BIAS.n7 4.5005
R30 BIAS.n22 BIAS.n0 3.95876
R31 BIAS.n25 BIAS.n24 3.77746
R32 BIAS.n22 BIAS.n21 2.27432
R33 BIAS.n7 BIAS.n6 2.21603
R34 BIAS.n17 BIAS.n16 2.21603
R35 BIAS.n24 BIAS.n23 1.1795
R36 BIAS.n7 BIAS.n0 0.975654
R37 BIAS.n18 BIAS.n14 0.142605
R38 BIAS.n8 BIAS.n3 0.142605
R39 BIAS.n9 BIAS.n2 0.142605
R40 BIAS.n5 BIAS.n2 0.142605
R41 BIAS.n21 BIAS.n20 0.079578
R42 BIAS.n6 BIAS.n3 0.0709482
R43 BIAS.n16 BIAS.n14 0.0709482
R44 BIAS.n20 BIAS.n11 0.068
R45 BIAS.n15 BIAS.n13 0.0545
R46 BIAS.n19 BIAS.n13 0.0545
R47 BIAS.n10 BIAS.n1 0.0458782
R48 BIAS.n4 BIAS.n1 0.0458782
R49 BIAS.n21 BIAS.n12 0.0123666
R50 BIAS.n17 BIAS.n0 0.00877641
R51 BIAS BIAS.n22 0.006125
R52 ICTRL.n0 ICTRL.t3 104.13
R53 ICTRL.n0 ICTRL.t4 99.1807
R54 ICTRL.n1 ICTRL.t0 99.1807
R55 ICTRL.n2 ICTRL.t1 41.0168
R56 ICTRL.n3 ICTRL.t2 31.7324
R57 ICTRL.n1 ICTRL.n0 4.9505
R58 ICTRL.n3 ICTRL.n2 3.038
R59 ICTRL.n2 ICTRL.n1 1.184
R60 ICTRL ICTRL.n3 0.0905
R61 IN2.n0 IN2.t2 130.244
R62 IN2.n1 IN2.t1 41.4905
R63 IN2.n0 IN2.t0 35.619
R64 IN2.n1 IN2.n0 9.9005
R65 IN2 IN2.n1 0.0905
R66 SENSE.n0 SENSE.t1 101.076
R67 SENSE.n0 SENSE.t0 65.578
R68 SENSE SENSE.n0 0.0905
R69 VSET VSET.t0 101.639
R70 IPB.n0 IPB.t2 68.1472
R71 IPB.n0 IPB.t0 64.0972
R72 IPB.n1 IPB.t1 32.6627
R73 IPB.n1 IPB.n0 0.509
R74 IPB IPB.n1 0.0905
R75 VDD.n2 VDD.t0 119.847
R76 VDD.n0 VDD.t2 119.847
R77 VDD.n0 VDD.t3 14.7281
R78 VDD.n1 VDD.t1 14.0452
R79 VDD.n1 VDD.n0 2.01762
R80 VDD.n2 VDD.n1 0.683375
R81 VDD VDD.n2 0.0905
R82 VIN.n107 VIN.t8 102.373
R83 VIN.n125 VIN.t10 102.373
R84 VIN.n74 VIN.t2 64.616
R85 VIN.n41 VIN.t0 64.616
R86 VIN.n57 VIN.t4 64.616
R87 VIN.n90 VIN.t7 64.616
R88 VIN.n80 VIN.t6 64.616
R89 VIN.n33 VIN.n23 21.1752
R90 VIN.n87 VIN.n12 18.9005
R91 VIN.n120 VIN.n119 18.3042
R92 VIN.n109 VIN.n1 18.3042
R93 VIN.n54 VIN.n53 18.3042
R94 VIN.n130 VIN.n129 18.3042
R95 VIN.n97 VIN.n96 18.3042
R96 VIN.n43 VIN.n23 18.3042
R97 VIN.n99 VIN.n98 18.3042
R98 VIN.n76 VIN.n12 18.3042
R99 VIN.n66 VIN.n65 18.3042
R100 VIN.n64 VIN.n63 18.3042
R101 VIN.n87 VIN.n86 18.3042
R102 VIN.n21 VIN.t3 9.59795
R103 VIN.n47 VIN.t5 9.59795
R104 VIN.n31 VIN.t1 9.59795
R105 VIN.n113 VIN.t11 6.17014
R106 VIN.n10 VIN.t9 6.17014
R107 VIN.n97 VIN.n87 4.9505
R108 VIN.n115 VIN.n114 4.57095
R109 VIN.n40 VIN.n37 4.57095
R110 VIN.n126 VIN.n125 4.57095
R111 VIN.n9 VIN.n6 4.57095
R112 VIN.n49 VIN.n48 4.57095
R113 VIN.n73 VIN.n70 4.57095
R114 VIN.n92 VIN.n91 4.57095
R115 VIN.n20 VIN.n17 4.57095
R116 VIN.n82 VIN.n81 4.57095
R117 VIN.n59 VIN.n58 4.57095
R118 VIN.n30 VIN.n27 4.57095
R119 VIN.n106 VIN.n103 4.57095
R120 VIN.n107 VIN.n106 4.5005
R121 VIN.n108 VIN.n105 4.5005
R122 VIN.n45 VIN.n44 4.5005
R123 VIN.n39 VIN.n38 4.5005
R124 VIN.n72 VIN.n71 4.5005
R125 VIN.n96 VIN.n95 4.5005
R126 VIN.n77 VIN.n76 4.5005
R127 VIN.n75 VIN.n72 4.5005
R128 VIN.n74 VIN.n73 4.5005
R129 VIN.n128 VIN.n127 4.5005
R130 VIN.n93 VIN.n89 4.5005
R131 VIN.n81 VIN.n80 4.5005
R132 VIN.n85 VIN.n84 4.5005
R133 VIN.n15 VIN.n14 4.5005
R134 VIN.n14 VIN.n13 4.5005
R135 VIN.n86 VIN.n85 4.5005
R136 VIN.n129 VIN.n128 4.5005
R137 VIN.n124 VIN.n123 4.5005
R138 VIN.n132 VIN.n121 4.5005
R139 VIN.n95 VIN.n94 4.5005
R140 VIN.n94 VIN.n5 4.5005
R141 VIN.n117 VIN.n116 4.5005
R142 VIN.n112 VIN.n111 4.5005
R143 VIN.n102 VIN.n101 4.5005
R144 VIN.n84 VIN.n83 4.5005
R145 VIN.n79 VIN.n78 4.5005
R146 VIN.n69 VIN.n68 4.5005
R147 VIN.n61 VIN.n16 4.5005
R148 VIN.n51 VIN.n50 4.5005
R149 VIN.n46 VIN.n45 4.5005
R150 VIN.n36 VIN.n35 4.5005
R151 VIN.n114 VIN.n113 4.5005
R152 VIN.n3 VIN.n2 4.5005
R153 VIN.n119 VIN.n118 4.5005
R154 VIN.n4 VIN.n3 4.5005
R155 VIN.n118 VIN.n117 4.5005
R156 VIN.n35 VIN.n34 4.5005
R157 VIN.n29 VIN.n28 4.5005
R158 VIN.n34 VIN.n33 4.5005
R159 VIN.n32 VIN.n29 4.5005
R160 VIN.n31 VIN.n30 4.5005
R161 VIN.n91 VIN.n90 4.5005
R162 VIN.n41 VIN.n40 4.5005
R163 VIN.n105 VIN.n104 4.5005
R164 VIN.n52 VIN.n51 4.5005
R165 VIN.n26 VIN.n25 4.5005
R166 VIN.n111 VIN.n110 4.5005
R167 VIN.n53 VIN.n52 4.5005
R168 VIN.n25 VIN.n24 4.5005
R169 VIN.n48 VIN.n47 4.5005
R170 VIN.n62 VIN.n61 4.5005
R171 VIN.n60 VIN.n56 4.5005
R172 VIN.n10 VIN.n9 4.5005
R173 VIN.n63 VIN.n62 4.5005
R174 VIN.n56 VIN.n55 4.5005
R175 VIN.n58 VIN.n57 4.5005
R176 VIN.n11 VIN.n8 4.5005
R177 VIN.n100 VIN.n99 4.5005
R178 VIN.n68 VIN.n67 4.5005
R179 VIN.n19 VIN.n18 4.5005
R180 VIN.n8 VIN.n7 4.5005
R181 VIN.n67 VIN.n66 4.5005
R182 VIN.n22 VIN.n19 4.5005
R183 VIN.n21 VIN.n20 4.5005
R184 VIN.n89 VIN.n88 4.5005
R185 VIN.n101 VIN.n100 4.5005
R186 VIN.n42 VIN.n39 4.5005
R187 VIN.n110 VIN.n109 4.5005
R188 VIN.n44 VIN.n43 4.5005
R189 VIN.n78 VIN.n77 4.5005
R190 VIN.n132 VIN.n0 3.28376
R191 VIN.n65 VIN.n12 2.8715
R192 VIN.n64 VIN.n54 2.8715
R193 VIN.n120 VIN.n1 2.5295
R194 VIN.n132 VIN.n131 2.27432
R195 VIN.n83 VIN.n82 2.21603
R196 VIN.n69 VIN.n17 2.21603
R197 VIN.n102 VIN.n6 2.21603
R198 VIN.n36 VIN.n27 2.21603
R199 VIN.n46 VIN.n37 2.21603
R200 VIN.n50 VIN.n49 2.21603
R201 VIN.n59 VIN.n16 2.21603
R202 VIN.n112 VIN.n103 2.21603
R203 VIN.n92 VIN.n5 2.21603
R204 VIN.n116 VIN.n115 2.21603
R205 VIN.n127 VIN.n126 2.21603
R206 VIN.n79 VIN.n70 2.21603
R207 VIN.n54 VIN.n23 2.0795
R208 VIN.n65 VIN.n64 2.0795
R209 VIN.n98 VIN.n97 1.8545
R210 VIN.n98 VIN.n1 1.5215
R211 VIN.n121 VIN.n120 1.454
R212 VIN.n116 VIN.n0 0.847054
R213 VIN.n83 VIN.n79 0.5605
R214 VIN.n83 VIN.n5 0.147167
R215 VIN.n128 VIN.n124 0.142605
R216 VIN.n35 VIN.n28 0.142605
R217 VIN.n34 VIN.n29 0.142605
R218 VIN.n30 VIN.n29 0.142605
R219 VIN.n45 VIN.n38 0.142605
R220 VIN.n44 VIN.n39 0.142605
R221 VIN.n40 VIN.n39 0.142605
R222 VIN.n51 VIN.n26 0.142605
R223 VIN.n52 VIN.n25 0.142605
R224 VIN.n48 VIN.n25 0.142605
R225 VIN.n62 VIN.n56 0.142605
R226 VIN.n58 VIN.n56 0.142605
R227 VIN.n68 VIN.n18 0.142605
R228 VIN.n67 VIN.n19 0.142605
R229 VIN.n20 VIN.n19 0.142605
R230 VIN.n78 VIN.n71 0.142605
R231 VIN.n77 VIN.n72 0.142605
R232 VIN.n73 VIN.n72 0.142605
R233 VIN.n84 VIN.n15 0.142605
R234 VIN.n85 VIN.n14 0.142605
R235 VIN.n81 VIN.n14 0.142605
R236 VIN.n101 VIN.n7 0.142605
R237 VIN.n100 VIN.n8 0.142605
R238 VIN.n9 VIN.n8 0.142605
R239 VIN.n111 VIN.n104 0.142605
R240 VIN.n110 VIN.n105 0.142605
R241 VIN.n106 VIN.n105 0.142605
R242 VIN.n117 VIN.n4 0.142605
R243 VIN.n118 VIN.n3 0.142605
R244 VIN.n114 VIN.n3 0.142605
R245 VIN.n94 VIN.n93 0.142605
R246 VIN.n95 VIN.n89 0.142605
R247 VIN.n91 VIN.n89 0.142605
R248 VIN.n61 VIN.n60 0.142605
R249 VIN.n79 VIN.n69 0.0855667
R250 VIN.n50 VIN.n16 0.0855667
R251 VIN.n46 VIN.n36 0.0855667
R252 VIN.n131 VIN.n130 0.079578
R253 VIN.n116 VIN.n112 0.0754333
R254 VIN.n115 VIN.n4 0.0709482
R255 VIN.n18 VIN.n17 0.0709482
R256 VIN.n28 VIN.n27 0.0709482
R257 VIN.n7 VIN.n6 0.0709482
R258 VIN.n38 VIN.n37 0.0709482
R259 VIN.n71 VIN.n70 0.0709482
R260 VIN.n93 VIN.n92 0.0709482
R261 VIN.n104 VIN.n103 0.0709482
R262 VIN.n60 VIN.n59 0.0709482
R263 VIN.n82 VIN.n15 0.0709482
R264 VIN.n49 VIN.n26 0.0709482
R265 VIN.n126 VIN.n124 0.0709482
R266 VIN.n130 VIN.n121 0.068
R267 VIN.n50 VIN.n46 0.0621
R268 VIN.n69 VIN.n16 0.0621
R269 VIN.n102 VIN.n5 0.0554333
R270 VIN.n99 VIN.n11 0.0545
R271 VIN.n11 VIN.n10 0.0545
R272 VIN.n47 VIN.n24 0.0545
R273 VIN.n53 VIN.n24 0.0545
R274 VIN.n42 VIN.n41 0.0545
R275 VIN.n43 VIN.n42 0.0545
R276 VIN.n32 VIN.n31 0.0545
R277 VIN.n33 VIN.n32 0.0545
R278 VIN.n109 VIN.n108 0.0545
R279 VIN.n108 VIN.n107 0.0545
R280 VIN.n96 VIN.n88 0.0545
R281 VIN.n90 VIN.n88 0.0545
R282 VIN.n119 VIN.n2 0.0545
R283 VIN.n113 VIN.n2 0.0545
R284 VIN.n22 VIN.n21 0.0545
R285 VIN.n66 VIN.n22 0.0545
R286 VIN.n57 VIN.n55 0.0545
R287 VIN.n125 VIN.n123 0.0545
R288 VIN.n75 VIN.n74 0.0545
R289 VIN.n63 VIN.n55 0.0545
R290 VIN.n129 VIN.n123 0.0545
R291 VIN.n76 VIN.n75 0.0545
R292 VIN.n86 VIN.n13 0.0545
R293 VIN.n80 VIN.n13 0.0545
R294 VIN.n112 VIN.n102 0.0455667
R295 VIN.n131 VIN.n122 0.0123666
R296 VIN.n127 VIN.n0 0.00877641
R297 VIN VIN.n132 0.006125
R298 VSS.n161 VSS.n135 16199.6
R299 VSS.n135 VSS.n134 1936.14
R300 VSS.n134 VSS.n5 1511.51
R301 VSS.n172 VSS.t20 945.197
R302 VSS.t20 VSS.n4 896.018
R303 VSS.n105 VSS.n104 621.611
R304 VSS.n104 VSS.n103 621.444
R305 VSS.n106 VSS.n103 621.444
R306 VSS.n132 VSS.n8 621.444
R307 VSS.n132 VSS.n7 621.444
R308 VSS.n79 VSS.n8 621.444
R309 VSS.n79 VSS.n7 621.444
R310 VSS.n170 VSS.n166 616.194
R311 VSS.n164 VSS.n163 616.194
R312 VSS.n170 VSS.n163 616.194
R313 VSS.n81 VSS.n80 458.818
R314 VSS.n40 VSS.n5 456.721
R315 VSS.n162 VSS.n161 427.63
R316 VSS.n156 VSS.t20 342.058
R317 VSS.n4 VSS.t13 328.252
R318 VSS.n133 VSS.n6 316.796
R319 VSS.n172 VSS.n171 213.851
R320 VSS.n80 VSS.t17 188.69
R321 VSS.t15 VSS.n6 188.69
R322 VSS.n139 VSS.n135 187.679
R323 VSS.n106 VSS.n105 144.732
R324 VSS.n61 VSS.n59 143.136
R325 VSS.n62 VSS.n58 142.139
R326 VSS.n59 VSS.n58 142.139
R327 VSS.n134 VSS.n133 125.584
R328 VSS.n149 VSS.n148 99.9027
R329 VSS.n171 VSS.t12 81.5237
R330 VSS.n165 VSS.n164 71.8966
R331 VSS.n153 VSS.n151 69.8005
R332 VSS.n159 VSS.n136 69.8005
R333 VSS.n141 VSS.n139 63.7434
R334 VSS.n146 VSS.n138 63.7434
R335 VSS.n134 VSS.t17 63.1073
R336 VSS.n152 VSS.n136 45.8061
R337 VSS.n151 VSS.n150 44.1603
R338 VSS.n148 VSS.n147 42.5146
R339 VSS.n140 VSS.n138 42.5146
R340 VSS.n161 VSS.n160 42.1718
R341 VSS.t0 VSS.n60 41.9665
R342 VSS.n81 VSS.t10 33.7241
R343 VSS.n62 VSS.n61 32.2971
R344 VSS.n60 VSS.n5 27.9253
R345 VSS.n33 VSS.n23 21.1209
R346 VSS.n123 VSS.n122 20.1989
R347 VSS.n125 VSS.n124 20.1989
R348 VSS.n112 VSS.n111 20.1989
R349 VSS.n96 VSS.n95 20.1989
R350 VSS.n85 VSS.n12 20.1989
R351 VSS.n72 VSS.n71 20.1989
R352 VSS.n70 VSS.n69 20.1989
R353 VSS.n42 VSS.n23 20.1989
R354 VSS.n55 VSS.n54 20.1962
R355 VSS.n138 VSS.t4 19.8861
R356 VSS.t8 VSS.n139 19.8861
R357 VSS.n140 VSS.t8 19.8861
R358 VSS.n150 VSS.t6 19.8861
R359 VSS.n148 VSS.t6 19.8861
R360 VSS.n147 VSS.t4 19.8861
R361 VSS.n136 VSS.t22 18.2404
R362 VSS.t19 VSS.n151 18.2404
R363 VSS.n160 VSS.t22 18.2404
R364 VSS.n152 VSS.t19 18.2404
R365 VSS.n71 VSS.n70 17.942
R366 VSS.n40 VSS.t2 16.5372
R367 VSS.n142 VSS.t9 15.7754
R368 VSS.n143 VSS.t5 15.0419
R369 VSS.n157 VSS.t21 14.5631
R370 VSS.n155 VSS.t14 14.5631
R371 VSS.n4 VSS.n2 13.8073
R372 VSS.n142 VSS.n141 13.6394
R373 VSS.n146 VSS.n145 13.6394
R374 VSS.n159 VSS.n158 13.5028
R375 VSS.n154 VSS.n153 13.5028
R376 VSS.n144 VSS.t7 13.4572
R377 VSS.n149 VSS.n137 13.2432
R378 VSS.n173 VSS.n3 13.1668
R379 VSS.n31 VSS.t3 12.6452
R380 VSS.n169 VSS.n167 12.4264
R381 VSS.n169 VSS.n168 12.4264
R382 VSS.n167 VSS.n3 12.397
R383 VSS.n168 VSS.n3 12.397
R384 VSS.n163 VSS.n162 10.9571
R385 VSS VSS.n175 9.76043
R386 VSS.n44 VSS.n40 9.15575
R387 VSS.n173 VSS.n172 6.77158
R388 VSS.n89 VSS.t18 6.49753
R389 VSS.n116 VSS.t16 6.49753
R390 VSS.n107 VSS.n106 6.42734
R391 VSS.n132 VSS.n131 6.42734
R392 VSS.n48 VSS.t1 5.82998
R393 VSS.n83 VSS.n81 5.33341
R394 VSS.n21 VSS.t11 5.28723
R395 VSS.n63 VSS.n62 4.90478
R396 VSS.n30 VSS.n27 4.57095
R397 VSS.n50 VSS.n49 4.57095
R398 VSS.n65 VSS.n64 4.57095
R399 VSS.n20 VSS.n17 4.57095
R400 VSS.n82 VSS.n76 4.57095
R401 VSS.n91 VSS.n90 4.57095
R402 VSS.n130 VSS.n129 4.57095
R403 VSS.n107 VSS.n101 4.57095
R404 VSS.n118 VSS.n117 4.57095
R405 VSS.n41 VSS.n37 4.57095
R406 VSS.n114 VSS.n113 4.5005
R407 VSS.n113 VSS.n112 4.5005
R408 VSS.n108 VSS.n102 4.5005
R409 VSS.n175 VSS.n1 4.5005
R410 VSS.n42 VSS.n41 4.5005
R411 VSS.n43 VSS.n39 4.5005
R412 VSS.n45 VSS.n44 4.5005
R413 VSS.n46 VSS.n45 4.5005
R414 VSS.n39 VSS.n38 4.5005
R415 VSS.n47 VSS.n46 4.5005
R416 VSS.n120 VSS.n119 4.5005
R417 VSS.n127 VSS.n11 4.5005
R418 VSS.n93 VSS.n92 4.5005
R419 VSS.n88 VSS.n87 4.5005
R420 VSS.n75 VSS.n74 4.5005
R421 VSS.n67 VSS.n16 4.5005
R422 VSS.n52 VSS.n51 4.5005
R423 VSS.n36 VSS.n35 4.5005
R424 VSS.n35 VSS.n34 4.5005
R425 VSS.n29 VSS.n28 4.5005
R426 VSS.n34 VSS.n33 4.5005
R427 VSS.n32 VSS.n29 4.5005
R428 VSS.n31 VSS.n30 4.5005
R429 VSS.n53 VSS.n52 4.5005
R430 VSS.n26 VSS.n25 4.5005
R431 VSS.n54 VSS.n53 4.5005
R432 VSS.n25 VSS.n24 4.5005
R433 VSS.n49 VSS.n48 4.5005
R434 VSS.n68 VSS.n67 4.5005
R435 VSS.n66 VSS.n57 4.5005
R436 VSS.n69 VSS.n68 4.5005
R437 VSS.n57 VSS.n56 4.5005
R438 VSS.n64 VSS.n63 4.5005
R439 VSS.n74 VSS.n73 4.5005
R440 VSS.n19 VSS.n18 4.5005
R441 VSS.n73 VSS.n72 4.5005
R442 VSS.n22 VSS.n19 4.5005
R443 VSS.n21 VSS.n20 4.5005
R444 VSS.n87 VSS.n86 4.5005
R445 VSS.n78 VSS.n77 4.5005
R446 VSS.n86 VSS.n85 4.5005
R447 VSS.n84 VSS.n78 4.5005
R448 VSS.n83 VSS.n82 4.5005
R449 VSS.n94 VSS.n93 4.5005
R450 VSS.n15 VSS.n14 4.5005
R451 VSS.n95 VSS.n94 4.5005
R452 VSS.n14 VSS.n13 4.5005
R453 VSS.n90 VSS.n89 4.5005
R454 VSS.n127 VSS.n126 4.5005
R455 VSS.n128 VSS.n10 4.5005
R456 VSS.n126 VSS.n125 4.5005
R457 VSS.n10 VSS.n9 4.5005
R458 VSS.n131 VSS.n130 4.5005
R459 VSS.n121 VSS.n120 4.5005
R460 VSS.n100 VSS.n99 4.5005
R461 VSS.n122 VSS.n121 4.5005
R462 VSS.n99 VSS.n98 4.5005
R463 VSS.n117 VSS.n116 4.5005
R464 VSS.n97 VSS.n0 4.5005
R465 VSS.n115 VSS.n0 3.73376
R466 VSS.n55 VSS.n23 3.12575
R467 VSS.n96 VSS.n12 2.9795
R468 VSS.n124 VSS.n96 2.8715
R469 VSS.n123 VSS.n97 2.804
R470 VSS.n110 VSS.n0 2.27432
R471 VSS.n175 VSS.n174 2.21775
R472 VSS.n114 VSS.n101 2.21603
R473 VSS.n129 VSS.n11 2.21603
R474 VSS.n119 VSS.n118 2.21603
R475 VSS.n36 VSS.n27 2.21603
R476 VSS.n92 VSS.n91 2.21603
R477 VSS.n47 VSS.n37 2.21603
R478 VSS.n65 VSS.n16 2.21603
R479 VSS.n75 VSS.n17 2.21603
R480 VSS.n88 VSS.n76 2.21603
R481 VSS.n51 VSS.n50 2.21603
R482 VSS.n124 VSS.n123 2.0795
R483 VSS.n158 VSS.n157 2.00075
R484 VSS.n156 VSS.n155 2.00075
R485 VSS.n154 VSS.n137 1.3505
R486 VSS.n158 VSS.n154 1.3505
R487 VSS.t0 VSS.n58 1.3005
R488 VSS.n168 VSS.n166 1.3005
R489 VSS.n167 VSS.n163 1.3005
R490 VSS.n166 VSS.n165 1.1469
R491 VSS.n71 VSS.n12 0.959
R492 VSS.n70 VSS.n55 0.92525
R493 VSS.n119 VSS.n115 0.887054
R494 VSS.n147 VSS.n146 0.743357
R495 VSS.n141 VSS.n140 0.743357
R496 VSS.n145 VSS.n143 0.734
R497 VSS.n144 VSS.n137 0.734
R498 VSS.n157 VSS.n156 0.70025
R499 VSS.n155 VSS.n1 0.63275
R500 VSS.n143 VSS.n142 0.617
R501 VSS.n145 VSS.n144 0.617
R502 VSS.n153 VSS.n152 0.578278
R503 VSS.n160 VSS.n159 0.578278
R504 VSS.n75 VSS.n16 0.5321
R505 VSS.n162 VSS.t20 0.465707
R506 VSS.n150 VSS.n149 0.347167
R507 VSS.n61 VSS.t0 0.296379
R508 VSS.t15 VSS.n103 0.217167
R509 VSS.n8 VSS.t17 0.217167
R510 VSS.n7 VSS.t17 0.217167
R511 VSS.n60 VSS.n59 0.2085
R512 VSS.n174 VSS.n173 0.202502
R513 VSS.n165 VSS.t12 0.15268
R514 VSS.n35 VSS.n28 0.142605
R515 VSS.n128 VSS.n127 0.142605
R516 VSS.n34 VSS.n29 0.142605
R517 VSS.n30 VSS.n29 0.142605
R518 VSS.n52 VSS.n26 0.142605
R519 VSS.n126 VSS.n10 0.142605
R520 VSS.n130 VSS.n10 0.142605
R521 VSS.n53 VSS.n25 0.142605
R522 VSS.n49 VSS.n25 0.142605
R523 VSS.n67 VSS.n66 0.142605
R524 VSS.n113 VSS.n102 0.142605
R525 VSS.n68 VSS.n57 0.142605
R526 VSS.n64 VSS.n57 0.142605
R527 VSS.n74 VSS.n18 0.142605
R528 VSS.n120 VSS.n100 0.142605
R529 VSS.n73 VSS.n19 0.142605
R530 VSS.n20 VSS.n19 0.142605
R531 VSS.n121 VSS.n99 0.142605
R532 VSS.n117 VSS.n99 0.142605
R533 VSS.n86 VSS.n78 0.142605
R534 VSS.n82 VSS.n78 0.142605
R535 VSS.n93 VSS.n15 0.142605
R536 VSS.n41 VSS.n39 0.142605
R537 VSS.n45 VSS.n39 0.142605
R538 VSS.n46 VSS.n38 0.142605
R539 VSS.n94 VSS.n14 0.142605
R540 VSS.n90 VSS.n14 0.142605
R541 VSS.n87 VSS.n77 0.142605
R542 VSS.n174 VSS.n2 0.135002
R543 VSS.n51 VSS.n47 0.0891
R544 VSS.n92 VSS.n88 0.0887667
R545 VSS.n92 VSS.n11 0.0855667
R546 VSS.n111 VSS.n110 0.079578
R547 VSS.n129 VSS.n128 0.0709482
R548 VSS.n18 VSS.n17 0.0709482
R549 VSS.n91 VSS.n15 0.0709482
R550 VSS.n50 VSS.n26 0.0709482
R551 VSS.n66 VSS.n65 0.0709482
R552 VSS.n77 VSS.n76 0.0709482
R553 VSS.n118 VSS.n100 0.0709482
R554 VSS.n38 VSS.n37 0.0709482
R555 VSS.n28 VSS.n27 0.0709482
R556 VSS.n102 VSS.n101 0.0709482
R557 VSS.n111 VSS.n97 0.068
R558 VSS.n2 VSS.n1 0.068
R559 VSS.n119 VSS.n11 0.0621
R560 VSS.n22 VSS.n21 0.0545
R561 VSS.n72 VSS.n22 0.0545
R562 VSS.n63 VSS.n56 0.0545
R563 VSS.n69 VSS.n56 0.0545
R564 VSS.n131 VSS.n9 0.0545
R565 VSS.n116 VSS.n98 0.0545
R566 VSS.n125 VSS.n9 0.0545
R567 VSS.n43 VSS.n42 0.0545
R568 VSS.n44 VSS.n43 0.0545
R569 VSS.n108 VSS.n107 0.0545
R570 VSS.n112 VSS.n108 0.0545
R571 VSS.n89 VSS.n13 0.0545
R572 VSS.n85 VSS.n84 0.0545
R573 VSS.n84 VSS.n83 0.0545
R574 VSS.n122 VSS.n98 0.0545
R575 VSS.n95 VSS.n13 0.0545
R576 VSS.n105 VSS.t15 0.0514603
R577 VSS.n104 VSS.n6 0.0477727
R578 VSS.n133 VSS.n132 0.0477727
R579 VSS.n80 VSS.n79 0.0477727
R580 VSS.n54 VSS.n24 0.0458782
R581 VSS.n48 VSS.n24 0.0458782
R582 VSS.n32 VSS.n31 0.0458782
R583 VSS.n33 VSS.n32 0.0458782
R584 VSS.n164 VSS.n3 0.041125
R585 VSS.n171 VSS.n170 0.041125
R586 VSS.n170 VSS.n169 0.041125
R587 VSS.n47 VSS.n36 0.0319
R588 VSS.n51 VSS.n16 0.0319
R589 VSS.n88 VSS.n75 0.0289
R590 VSS.n110 VSS.n109 0.0123666
R591 VSS.n115 VSS.n114 0.00877641
R592 VSS VSS.n0 0.006125
R593 VX.n0 VX.t1 13.142
R594 VX.n1 VX.t2 13.142
R595 VX.n0 VX.t0 13.0779
R596 VX.n1 VX.n0 1.3505
R597 VX VX.n1 0.068
R598 GP.n0 GP.t2 48.6459
R599 GP.n3 GP.n2 12.771
R600 GP.n0 GP.t1 12.6241
R601 GP.n3 GP.n0 1.36738
R602 GP.n2 GP.t0 0.6557
R603 GP.n2 GP.n1 0.4541
R604 GP GP.n3 0.068
R605 GB.n0 GB.t3 62.0963
R606 GB.n0 GB.t2 50.1597
R607 GB.n1 GB.t4 47.4597
R608 GB.n5 GB.n4 13.0552
R609 GB.n2 GB.t0 12.9083
R610 GB.n2 GB.n1 1.47087
R611 GB.n5 GB.n2 1.36738
R612 GB.n1 GB.n0 1.3505
R613 GB.n4 GB.t1 0.6557
R614 GB.n4 GB.n3 0.4541
R615 GB GB.n5 0.068
R616 DI.n0 DI.t1 51.0678
R617 DI.n0 DI.t2 44.4281
R618 DI.n2 DI.t0 13.0005
R619 DI.t0 DI.n1 5.98411
R620 DI.n2 DI.n0 2.0255
R621 DI DI.n2 0.068
R622 IN1.n0 IN1.t3 72.1438
R623 IN1.n0 IN1.t1 67.1938
R624 IN1.n4 IN1.n3 39.1039
R625 IN1.n1 IN1.t2 33.2506
R626 IN1.n4 IN1.n1 9.9005
R627 IN1.n1 IN1.n0 1.184
R628 IN1 IN1.n4 0.068
R629 IN1.n3 IN1.t0 0.0187
R630 IN1.n3 IN1.n2 0.0131
R631 ITAIL.n0 ITAIL.t0 44.5457
R632 ITAIL.n0 ITAIL.t1 39.5957
R633 ITAIL.n3 ITAIL.n2 30.2033
R634 ITAIL.n3 ITAIL.n0 5.7425
R635 ITAIL.n2 ITAIL.t2 0.0915
R636 ITAIL ITAIL.n3 0.068
R637 ITAIL.n2 ITAIL.n1 0.0635
C0 BIAS VSS 2.0525656337359491e-14
C1 BIAS.n0 VSS 2.1418245171875607e-15
C2 BIAS.n1 VSS 1.8360727739326007e-17
C3 BIAS.n10 VSS 5.2151771041207398e-16
C4 BIAS.n11 VSS 4.5913618734152327e-16
C5 BIAS.n12 VSS 7.294721055549726e-18
C6 BIAS.n13 VSS 1.5429179792795639e-17
C7 BIAS.n14 VSS 5.8630958930607412e-18
C8 BIAS.n15 VSS 1.0904399266629196e-15
C9 BIAS.n16 VSS 4.7143783580591324e-18
C10 BIAS.n17 VSS 2.6743844335971118e-17
C11 BIAS.n18 VSS 4.788178153114276e-18
C12 BIAS.n19 VSS 4.2875813216766225e-16
C13 BIAS.n2 VSS 5.8630958930607412e-18
C14 BIAS.n20 VSS 2.7516672559154588e-16
C15 BIAS.n21 VSS 1.7560211973332865e-18
C16 BIAS.n22 VSS 1.4502820737423238e-15
C17 BIAS.n23 VSS 2.69391967346465e-16
C18 BIAS.n24 VSS 3.2401996885718672e-16
C19 BIAS.n25 VSS 2.388203265268882e-14
C20 BIAS.n3 VSS 5.8630958930607412e-18
C21 BIAS.n4 VSS 3.8398861217148865e-16
C22 BIAS.n5 VSS 4.862003187497413e-18
C23 BIAS.n6 VSS 4.7143783580591324e-18
C24 BIAS.n7 VSS 4.6631425222308361e-15
C25 BIAS.n8 VSS 4.788178153114276e-18
C26 BIAS.n9 VSS 4.788178153114276e-18
C27 BIAS.t0 VSS 3.2358080455008711e-16
C28 BIAS.t1 VSS 1.2181913092385385e-16
C29 BIAS.t2 VSS 9.2463773320319237e-17
C30 BIAS.t3 VSS 2.4512081997408905e-15
C31 BIAS.t4 VSS 1.2110712948113649e-16
C32 BIAS.t5 VSS 1.6573455206070259e-16
C33 DATA VSS 5.1379399999999998e-16
C34 DI VSS 2.2179081460834401e-17
C35 DI.n0 VSS 1.0017037620543691e-15
C36 DI.n1 VSS 2.4159379427858677e-17
C37 DI.n2 VSS 3.233882360543154e-16
C38 DI.t0 VSS 1.1136933376781814e-16
C39 DI.t1 VSS 4.2534900112241549e-16
C40 DI.t2 VSS 4.4643120611238895e-16
C41 DISABLE VSS 2.0889683081542602e-17
C42 DISABLE.n0 VSS 1.0741847677186728e-14
C43 DISABLE.t0 VSS 2.1323414312085483e-15
C44 DISABLE.t1 VSS 2.1740212085231821e-15
C45 DUMMY VSS 3.5341178074259183e-16
C46 DUMMY.t0 VSS 3.981542192574083e-16
C47 GB VSS 1.3680840692452363e-17
C48 GB.n0 VSS 1.6370626537839774e-15
C49 GB.n1 VSS 7.546302885818571e-16
C50 GB.n2 VSS 5.0442576867905278e-16
C51 GB.n3 VSS 2.1987007786293946e-17
C52 GB.n4 VSS 3.1345590107860386e-16
C53 GB.n5 VSS 3.7848174079287258e-16
C54 GB.t0 VSS 4.5674122831800634e-16
C55 GB.t1 VSS 3.1759141601949915e-17
C56 GB.t2 VSS 3.8270671190802128e-16
C57 GB.t3 VSS 3.2867224966964272e-16
C58 GB.t4 VSS 3.4159646710727039e-16
C59 GP VSS 1.2859617104615066e-17
C60 GP.n0 VSS 1.0167393392011568e-15
C61 GP.n1 VSS 2.0667298396768527e-17
C62 GP.n2 VSS 2.7518348218178656e-16
C63 GP.n3 VSS 3.3333496476805066e-16
C64 GP.t0 VSS 2.9852693888583838e-17
C65 GP.t1 VSS 4.0955474366671917e-16
C66 GP.t2 VSS 3.3197786079231928e-16
C67 ICTRL VSS 1.4512356912415831e-18
C68 ICTRL.n0 VSS 3.6379660053652396e-15
C69 ICTRL.n1 VSS 1.8475561644452366e-15
C70 ICTRL.n2 VSS 3.5722957864940048e-16
C71 ICTRL.n3 VSS 2.549901484004264e-16
C72 ICTRL.t0 VSS 1.1391117870714203e-14
C73 ICTRL.t1 VSS 1.1211990390893192e-15
C74 ICTRL.t2 VSS 3.7964527949815344e-16
C75 ICTRL.t3 VSS 1.1478426807432574e-14
C76 ICTRL.t4 VSS 1.1391117870714203e-14
C77 IN1 VSS 4.6547264064003637e-18
C78 IN1.n0 VSS 4.8840704826937861e-15
C79 IN1.n1 VSS 9.7767372551912539e-16
C80 IN1.n2 VSS 2.992331463145452e-16
C81 IN1.n3 VSS 2.3016051817190565e-15
C82 IN1.n4 VSS 1.1002366641387368e-15
C83 IN1.t0 VSS 4.3222474177493821e-16
C84 IN1.t1 VSS 1.6496732569569281e-14
C85 IN1.t2 VSS 1.7589345681961068e-15
C86 IN1.t3 VSS 1.6669234193668027e-14
C87 IN2 VSS 1.1442253772062437e-17
C88 IN2.n0 VSS 7.4655333727808292e-15
C89 IN2.n1 VSS 3.3417311024868609e-15
C90 IN2.t0 VSS 5.2257909586942371e-15
C91 IN2.t1 VSS 8.8763706225041579e-15
C92 IN2.t2 VSS 2.5048316897618577e-15
C93 IPB VSS 5.9481529904332222e-18
C94 IPB.n0 VSS 3.9655594817821573e-15
C95 IPB.n1 VSS 9.7084961832342254e-16
C96 IPB.t0 VSS 4.5667753501244835e-15
C97 IPB.t1 VSS 1.5942294511304933e-15
C98 IPB.t2 VSS 4.6878379456490129e-15
C99 ITAIL VSS 9.8071468062571662e-18
C100 ITAIL.n0 VSS 4.2135358165408428e-15
C101 ITAIL.n1 VSS 1.2609245730769175e-16
C102 ITAIL.n2 VSS 1.8175438008435657e-15
C103 ITAIL.n3 VSS 1.5575788551739724e-15
C104 ITAIL.t0 VSS 6.6422000880348383e-15
C105 ITAIL.t1 VSS 6.414508539092244e-15
C106 ITAIL.t2 VSS 1.8213329620058983e-16
C107 KRET VSS 2.7675567364080952e-15
C108 KRET.t0 VSS 2.1303932635919043e-15
C109 OUT VSS 1.6466359315051374e-17
C110 OUT.n0 VSS 1.9087204877710837e-15
C111 OUT.t0 VSS 6.3552119310534405e-16
C112 OUT.t1 VSS 7.9796195980852146e-16
C113 SENSE VSS 1.8810642236125377e-18
C114 SENSE.n0 VSS 3.1170098362838271e-15
C115 SENSE.t0 VSS 1.7353276386880428e-15
C116 SENSE.t1 VSS 1.4810781460804515e-14
C117 VDD VSS 1.1741043787814261e-17
C118 VDD.n0 VSS 2.937022934303338e-15
C119 VDD.n1 VSS 5.8684221162364178e-16
C120 VDD.n2 VSS 2.3584246324042782e-15
C121 VDD.t0 VSS 1.4208039098418585e-15
C122 VDD.t1 VSS 5.4204999780447369e-16
C123 VDD.t2 VSS 1.4208039098418585e-15
C124 VDD.t3 VSS 5.6203136039273769e-16
C125 VIN VSS 2.0906177316231692e-17
C126 VIN.n0 VSS 5.3053434912034867e-15
C127 VIN.n1 VSS 1.1205052980363083e-15
C128 VIN.n10 VSS 3.0255965118999616e-15
C129 VIN.n100 VSS 1.7378246260740209e-17
C130 VIN.n101 VSS 1.7378246260740209e-17
C131 VIN.n102 VSS 4.1998964783831902e-15
C132 VIN.n103 VSS 1.7110363588696485e-17
C133 VIN.n104 VSS 2.1279467984787494e-17
C134 VIN.n105 VSS 2.1279467984787494e-17
C135 VIN.n106 VSS 1.7646128932783926e-17
C136 VIN.n107 VSS 1.1600086686917707e-14
C137 VIN.n108 VSS 5.5998666622321717e-17
C138 VIN.n109 VSS 1.3324260344151046e-15
C139 VIN.n11 VSS 5.5998666622321717e-17
C140 VIN.n110 VSS 1.7378246260740209e-17
C141 VIN.n111 VSS 1.7378246260740209e-17
C142 VIN.n112 VSS 5.0398814033253295e-15
C143 VIN.n113 VSS 3.0255965118999616e-15
C144 VIN.n114 VSS 1.7646128932783926e-17
C145 VIN.n115 VSS 1.7110363588696485e-17
C146 VIN.n116 VSS 9.665237768297738e-15
C147 VIN.n117 VSS 1.7378246260740209e-17
C148 VIN.n118 VSS 1.7378246260740209e-17
C149 VIN.n119 VSS 1.3324260344151046e-15
C150 VIN.n12 VSS 2.5906513129410298e-15
C151 VIN.n120 VSS 1.1149041788625021e-15
C152 VIN.n121 VSS 1.2618350450286422e-16
C153 VIN.n122 VSS 2.6129854238174884e-17
C154 VIN.n123 VSS 5.5998666622321717e-17
C155 VIN.n124 VSS 2.1279467984787494e-17
C156 VIN.n125 VSS 1.1600368150192772e-14
C157 VIN.n126 VSS 1.7110363588696485e-17
C158 VIN.n127 VSS 9.7064017722760894e-17
C159 VIN.n128 VSS 1.7378246260740209e-17
C160 VIN.n129 VSS 1.3324260344151046e-15
C161 VIN.n13 VSS 5.5998666622321717e-17
C162 VIN.n130 VSS 7.9680142196519361e-16
C163 VIN.n131 VSS 6.3732995957850404e-18
C164 VIN.n132 VSS 4.3680144925798968e-15
C165 VIN.n14 VSS 2.1279467984787494e-17
C166 VIN.n15 VSS 2.1279467984787494e-17
C167 VIN.n16 VSS 6.1598519211390131e-15
C168 VIN.n17 VSS 1.7110363588696485e-17
C169 VIN.n18 VSS 2.1279467984787494e-17
C170 VIN.n19 VSS 2.1279467984787494e-17
C171 VIN.n2 VSS 5.5998666622321717e-17
C172 VIN.n20 VSS 1.7646128932783926e-17
C173 VIN.n21 VSS 4.9119985642992568e-15
C174 VIN.n22 VSS 5.5998666622321717e-17
C175 VIN.n23 VSS 2.0953322414805184e-15
C176 VIN.n24 VSS 5.5998666622321717e-17
C177 VIN.n25 VSS 2.1279467984787494e-17
C178 VIN.n26 VSS 2.1279467984787494e-17
C179 VIN.n27 VSS 1.7110363588696485e-17
C180 VIN.n28 VSS 2.1279467984787494e-17
C181 VIN.n29 VSS 2.1279467984787494e-17
C182 VIN.n3 VSS 2.1279467984787494e-17
C183 VIN.n30 VSS 1.7646128932783926e-17
C184 VIN.n31 VSS 4.9119985642992568e-15
C185 VIN.n32 VSS 5.5998666622321717e-17
C186 VIN.n33 VSS 1.4736220863517823e-15
C187 VIN.n34 VSS 1.7378246260740209e-17
C188 VIN.n35 VSS 1.7378246260740209e-17
C189 VIN.n36 VSS 4.4126897509146893e-15
C190 VIN.n37 VSS 1.7110363588696485e-17
C191 VIN.n38 VSS 2.1279467984787494e-17
C192 VIN.n39 VSS 2.1279467984787494e-17
C193 VIN.n4 VSS 2.1279467984787494e-17
C194 VIN.n40 VSS 1.7646128932783926e-17
C195 VIN.n41 VSS 4.2299567561602008e-14
C196 VIN.n42 VSS 5.5998666622321717e-17
C197 VIN.n43 VSS 1.3324260344151046e-15
C198 VIN.n44 VSS 1.7378246260740209e-17
C199 VIN.n45 VSS 1.7378246260740209e-17
C200 VIN.n46 VSS 6.1598519211390131e-15
C201 VIN.n47 VSS 4.9119985642992568e-15
C202 VIN.n48 VSS 1.7646128932783926e-17
C203 VIN.n49 VSS 1.7110363588696485e-17
C204 VIN.n5 VSS 8.4669782405245488e-15
C205 VIN.n50 VSS 6.1598519211390131e-15
C206 VIN.n51 VSS 1.7378246260740209e-17
C207 VIN.n52 VSS 1.7378246260740209e-17
C208 VIN.n53 VSS 1.3324260344151046e-15
C209 VIN.n54 VSS 1.195163431747469e-15
C210 VIN.n55 VSS 5.5998666622321717e-17
C211 VIN.n56 VSS 2.1279467984787494e-17
C212 VIN.n57 VSS 4.2299567561602008e-14
C213 VIN.n58 VSS 1.7646128932783926e-17
C214 VIN.n59 VSS 1.7110363588696485e-17
C215 VIN.n6 VSS 1.7110363588696485e-17
C216 VIN.n60 VSS 2.1279467984787494e-17
C217 VIN.n61 VSS 1.7378246260740209e-17
C218 VIN.n62 VSS 1.7378246260740209e-17
C219 VIN.n63 VSS 1.3324260344151046e-15
C220 VIN.n64 VSS 1.195163431747469e-15
C221 VIN.n65 VSS 1.195163431747469e-15
C222 VIN.n66 VSS 1.3324260344151046e-15
C223 VIN.n67 VSS 1.7378246260740209e-17
C224 VIN.n68 VSS 1.7378246260740209e-17
C225 VIN.n69 VSS 6.1598519211390131e-15
C226 VIN.n7 VSS 2.1279467984787494e-17
C227 VIN.n70 VSS 1.7110363588696485e-17
C228 VIN.n71 VSS 2.1279467984787494e-17
C229 VIN.n72 VSS 2.1279467984787494e-17
C230 VIN.n73 VSS 1.7646128932783926e-17
C231 VIN.n74 VSS 4.2299567561602008e-14
C232 VIN.n75 VSS 5.5998666622321717e-17
C233 VIN.n76 VSS 1.3324260344151046e-15
C234 VIN.n77 VSS 1.7378246260740209e-17
C235 VIN.n78 VSS 1.7378246260740209e-17
C236 VIN.n79 VSS 2.7092177175624303e-14
C237 VIN.n8 VSS 2.1279467984787494e-17
C238 VIN.n80 VSS 4.2299567561602008e-14
C239 VIN.n81 VSS 1.7646128932783926e-17
C240 VIN.n82 VSS 1.7110363588696485e-17
C241 VIN.n83 VSS 2.9679246868390128e-14
C242 VIN.n84 VSS 1.7378246260740209e-17
C243 VIN.n85 VSS 1.7378246260740209e-17
C244 VIN.n86 VSS 1.3324260344151046e-15
C245 VIN.n87 VSS 2.7631320079012529e-15
C246 VIN.n88 VSS 5.5998666622321717e-17
C247 VIN.n89 VSS 2.1279467984787494e-17
C248 VIN.n9 VSS 1.7646128932783926e-17
C249 VIN.n90 VSS 4.2299567561602008e-14
C250 VIN.n91 VSS 1.7646128932783926e-17
C251 VIN.n92 VSS 1.7110363588696485e-17
C252 VIN.n93 VSS 2.1279467984787494e-17
C253 VIN.n94 VSS 1.7378246260740209e-17
C254 VIN.n95 VSS 1.7378246260740209e-17
C255 VIN.n96 VSS 1.3324260344151046e-15
C256 VIN.n97 VSS 1.348976074988964e-15
C257 VIN.n98 VSS 1.0645011428801229e-15
C258 VIN.n99 VSS 1.3324260344151046e-15
C259 VIN.t0 VSS 9.9938461419368738e-14
C260 VIN.t1 VSS 9.8084322094873835e-15
C261 VIN.t10 VSS 1.0435110191421028e-14
C262 VIN.t11 VSS 2.9590093376013079e-15
C263 VIN.t2 VSS 9.9938461419368738e-14
C264 VIN.t3 VSS 9.8084322094873835e-15
C265 VIN.t4 VSS 9.9938461419368738e-14
C266 VIN.t5 VSS 9.8084322094873835e-15
C267 VIN.t6 VSS 9.9938461419368738e-14
C268 VIN.t7 VSS 9.9938461419368738e-14
C269 VIN.t8 VSS 1.0435110191421028e-14
C270 VIN.t9 VSS 2.9590093376013079e-15
C271 VSET VSS 1.2679285545975405e-15
C272 VSET.t0 VSS 8.1159714454024592e-15
C273 VX VSS 1.5899840807910551e-17
C274 VX.n0 VSS 8.3708462440838158e-16
C275 VX.n1 VSS 3.9966294513386825e-16
C276 VX.t0 VSS 6.5512379342519835e-16
C277 VX.t1 VSS 3.6168939811232071e-16
C278 VX.t2 VSS 3.6168939811232071e-16
C279 VX DUMMY 3.3480599999999999e-16
C280 GB OUT 6.5083600000000007e-17
C281 ITAIL VSET 5.6067100000000007e-15
C282 GP VDD 1.0070900000000002e-15
C283 BIAS VX 4.0741800000000004e-16
C284 DI GB 1.6138800000000001e-16
C285 VIN IPB 1.22128e-14
C286 IN2 IN1 2.9566800000000002e-15
C287 IN2 VIN 1.2069800000000001e-14
C288 ICTRL BIAS 7.1750700000000001e-15
C289 GP OUT 1.7895500000000002e-16
C290 GB VX 2.85847e-16
C291 ITAIL IN1 6.9786699999999999e-16
C292 OUT VDD 6.5634800000000003e-18
C293 BIAS DUMMY 1.2036600000000001e-18
C294 DI GP 1.13075e-19
C295 VIN ITAIL 2.3412400000000005e-14
C296 IN2 SENSE 6.0061200000000007e-15
C297 DI VDD 4.64497e-16
C298 ICTRL VIN 4.2531300000000009e-14
C299 GB DUMMY 2.0769700000000003e-16
C300 GP VX 1.5857600000000001e-16
C301 ITAIL SENSE 5.6061099999999999e-15
C302 VSET IN1 5.6043800000000006e-15
C303 VX VDD 2.9333199999999999e-19
C304 VIN VSET 4.3383900000000007e-15
C305 ICTRL SENSE 5.7641700000000007e-15
C306 BIAS GB 1.0092300000000001e-16
C307 BIAS VIN 1.4526299999999999e-14
C308 BIAS DISABLE 1.2698399999999999e-15
C309 OUT VX 2.8288800000000001e-16
C310 GP DUMMY 8.2815100000000015e-18
C311 VIN IN1 1.2516600000000001e-14
C312 IPB ITAIL 1.3540800000000001e-15
C313 IN2 ITAIL 1.13766e-16
C314 IN2 ICTRL 1.1530500000000001e-15
C315 OUT DUMMY 2.6675400000000002e-19
C316 IN1 SENSE 6.9340500000000005e-17
C317 GB GP 9.4624600000000007e-16
C318 VIN SENSE 1.6116700000000003e-14
C319 GB VDD 1.7549500000000002e-15
C320 BIAS OUT 2.1524100000000004e-16
C321 DISABLE KRET 5.27759e-16
.ends nrz_reference_integrated
