* NGSPICE file created from nrz_reference_integrated.ext - technology: gf180mcuD

.subckt nrz_reference_integrated DATA OUT VDD VSS BIAS DUMMY VIN VSET SENSE IPB IN2
+ ICTRL DISABLE KRET
X0 VSS DI GB VSS nfet_06v0 ad=1.1p pd=5.88u as=1.1p ps=5.88u w=2.5u l=0.7u
X1 VIN ICTRL ICTRL VIN pfet_06v0 ad=44p pd=0.20088m as=44p ps=0.20088m w=100u l=10u
X2 VIN ICTRL BIAS VIN pfet_06v0 ad=44p pd=0.20088m as=44p ps=0.20088m w=100u l=10u
X3 DI DATA VSS ppolyf_u_1k_6p0 r_width=1u r_length=58u
X4 VX GB DUMMY VSS nfet_06v0 ad=1.1p pd=5.88u as=1.1p ps=5.88u w=2.5u l=0.7u
X5 VIN IPB IPB VIN pfet_06v0 ad=8.8p pd=40.88u as=8.8p ps=40.88u w=20u l=4u
X6 VSS DISABLE BIAS VSS nfet_06v0 ad=4.4p pd=20.88u as=4.4p ps=20.88u w=10u l=0.7u
X7 ITAIL SENSE IN2 VIN pfet_06v0 ad=44p pd=0.20088m as=44p ps=0.20088m w=100u l=10u
X8 VSS IN2 ICTRL VSS nfet_06v0 ad=8.8p pd=40.88u as=8.8p ps=40.88u w=20u l=1u
X9 ITAIL VSET IN1 VIN pfet_06v0 ad=44p pd=0.20088m as=44p ps=0.20088m w=100u l=10u
X10 VIN IPB ITAIL VIN pfet_06v0 ad=8.8p pd=40.88u as=8.8p ps=40.88u w=20u l=4u
X11 VSS BIAS OUT VSS nfet_03v3 ad=0.88p pd=4.88u as=0.88p ps=4.88u w=2u l=1u
X12 VIN ICTRL SENSE VIN pfet_06v0 ad=44p pd=0.20088m as=44p ps=0.20088m w=100u l=10u
X13 VSS DISABLE KRET VSS nfet_06v0 ad=0.44p pd=2.88u as=0.44p ps=2.88u w=1u l=0.7u
X14 VX GP OUT VSS nfet_06v0 ad=1.1p pd=5.88u as=1.1p ps=5.88u w=2.5u l=0.7u
X15 VDD DI GB VDD pfet_06v0 ad=1.7292p pd=8.74u as=1.7292p ps=8.74u w=3.93u l=0.55u
X16 VSS IN1 IN2 VSS nfet_06v0 ad=22p pd=0.10088m as=22p ps=0.10088m w=50u l=10u
X17 VSS BIAS VX VSS nfet_03v3 ad=2.5344p pd=12.4u as=2.5344p ps=12.4u w=5.76u l=1u
X18 VSS BIAS BIAS VSS nfet_03v3 ad=0.88p pd=4.88u as=0.88p ps=4.88u w=2u l=1u
X19 VSS GB GP VSS nfet_06v0 ad=1.1p pd=5.88u as=1.1p ps=5.88u w=2.5u l=0.7u
X20 VSS IN1 IN1 VSS nfet_06v0 ad=22p pd=0.10088m as=22p ps=0.10088m w=50u l=10u
X21 VDD GB GP VDD pfet_06v0 ad=1.7292p pd=8.74u as=1.7292p ps=8.74u w=3.93u l=0.55u
C0 ITAIL VIN 23.4124f
C1 ICTRL BIAS 7.17507f
C2 VIN ICTRL 42.5313f
C3 VX VDD 0
C4 IN1 IN2 2.95668f
C5 DI GP 0
C6 VX BIAS 0.40742f
C7 VIN IN2 12.0698f
C8 GP VDD 1.00709f
C9 ITAIL IN2 0.11377f
C10 DI GB 0.16139f
C11 BIAS DUMMY 0.0012f
C12 VDD OUT 0.00656f
C13 IN2 ICTRL 1.15305f
C14 IN1 SENSE 0.06934f
C15 GB VDD 1.75495f
C16 BIAS OUT 0.21524f
C17 VIN SENSE 16.1167f
C18 GB BIAS 0.10092f
C19 ITAIL SENSE 5.60611f
C20 IN1 VSET 5.60438f
C21 DISABLE KRET 0.52776f
C22 VX DUMMY 0.33481f
C23 SENSE ICTRL 5.76417f
C24 VIN VSET 4.33839f
C25 ITAIL VSET 5.60671f
C26 DI VDD 0.4645f
C27 GP VX 0.15858f
C28 SENSE IN2 6.00612f
C29 VX OUT 0.28289f
C30 GP DUMMY 0.00828f
C31 VIN IPB 12.2128f
C32 GB VX 0.28585f
C33 ITAIL IPB 1.35408f
C34 OUT DUMMY 0
C35 BIAS DISABLE 1.26984f
C36 GP OUT 0.17896f
C37 GB DUMMY 0.2077f
C38 IN1 VIN 12.5166f
C39 GB GP 0.94625f
C40 ITAIL IN1 0.69787f
C41 GB OUT 0.06508f
C42 VIN BIAS 14.5263f
C43 DUMMY VSS 3.92281f
C44 OUT VSS 38.24458f
C45 DATA VSS 0.51379f
C46 KRET VSS 4.89795f
C47 IN2 VSS 24.80828f
C48 SENSE VSS 9.31455f
C49 VDD VSS 9.83972f
C50 VIN VSS 1.00725p
C51 VX VSS 7.01748f
C52 ITAIL VSS 35.48785f
.ends
