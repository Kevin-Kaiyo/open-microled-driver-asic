* NGSPICE file created from nrz_reference_integrated.ext - technology: gf180mcuD

X0 VSS DI GB VSS nfet_06v0 ad=1.1p pd=5.88u as=1.1p ps=5.88u w=2.5u l=0.7u
X1 VIN ICTRL ICTRL VIN pfet_06v0 ad=44p pd=0.20088m as=44p ps=0.20088m w=100u l=10u
X2 VIN ICTRL BIAS VIN pfet_06v0 ad=44p pd=0.20088m as=44p ps=0.20088m w=100u l=10u
X3 DI DATA VSS ppolyf_u_1k_6p0 r_width=1u r_length=58u
X4 VX GB DUMMY VSS nfet_06v0 ad=1.1p pd=5.88u as=1.1p ps=5.88u w=2.5u l=0.7u
X5 VIN IPB IPB VIN pfet_06v0 ad=8.8p pd=40.88u as=8.8p ps=40.88u w=20u l=4u
X6 VSS DISABLE BIAS VSS nfet_06v0 ad=4.4p pd=20.88u as=4.4p ps=20.88u w=10u l=0.7u
X7 ITAIL SENSE IN2 VIN pfet_06v0 ad=44p pd=0.20088m as=44p ps=0.20088m w=100u l=10u
X8 VSS IN2 ICTRL VSS nfet_06v0 ad=8.8p pd=40.88u as=8.8p ps=40.88u w=20u l=1u
X9 ITAIL VSET IN1 VIN pfet_06v0 ad=44p pd=0.20088m as=44p ps=0.20088m w=100u l=10u
X10 VIN IPB ITAIL VIN pfet_06v0 ad=8.8p pd=40.88u as=8.8p ps=40.88u w=20u l=4u
X11 VSS BIAS OUT VSS nfet_03v3 ad=0.88p pd=4.88u as=0.88p ps=4.88u w=2u l=1u
X12 VIN ICTRL SENSE VIN pfet_06v0 ad=44p pd=0.20088m as=44p ps=0.20088m w=100u l=10u
X13 VSS DISABLE KRET VSS nfet_06v0 ad=0.44p pd=2.88u as=0.44p ps=2.88u w=1u l=0.7u
X14 VX GP OUT VSS nfet_06v0 ad=1.1p pd=5.88u as=1.1p ps=5.88u w=2.5u l=0.7u
X15 VDD DI GB VDD pfet_06v0 ad=1.7292p pd=8.74u as=1.7292p ps=8.74u w=3.93u l=0.55u
X16 VSS IN1 IN2 VSS nfet_06v0 ad=22p pd=0.10088m as=22p ps=0.10088m w=50u l=10u
X17 VSS BIAS VX VSS nfet_03v3 ad=2.5344p pd=12.4u as=2.5344p ps=12.4u w=5.76u l=1u
X18 VSS BIAS BIAS VSS nfet_03v3 ad=0.88p pd=4.88u as=0.88p ps=4.88u w=2u l=1u
X19 VSS GB GP VSS nfet_06v0 ad=1.1p pd=5.88u as=1.1p ps=5.88u w=2.5u l=0.7u
X20 VSS IN1 IN1 VSS nfet_06v0 ad=22p pd=0.10088m as=22p ps=0.10088m w=50u l=10u
X21 VDD GB GP VDD pfet_06v0 ad=1.7292p pd=8.74u as=1.7292p ps=8.74u w=3.93u l=0.55u
C0 IN1 IN2 2.95668f
C1 IN1 SENSE 0.06934f
C2 GB VDD 1.75495f
C3 VX BIAS 0.40742f
C4 VIN IN2 12.0698f
C5 VIN SENSE 16.1167f
C6 ITAIL IN2 0.11377f
C7 ITAIL SENSE 5.60611f
C8 IN1 VSET 5.60438f
C9 ICTRL BIAS 7.17507f
C10 VDD OUT 0.00656f
C11 VIN VSET 4.33839f
C12 ITAIL VSET 5.60671f
C13 DI VDD 0.4645f
C14 GP VX 0.15858f
C15 GB BIAS 0.10092f
C16 VIN IPB 12.2128f
C17 GB VX 0.28585f
C18 ITAIL IPB 1.35408f
C19 BIAS DUMMY 0.0012f
C20 IN2 ICTRL 1.15305f
C21 VX DUMMY 0.33481f
C22 SENSE ICTRL 5.76417f
C23 IN1 VIN 12.5166f
C24 GB GP 0.94625f
C25 ITAIL IN1 0.69787f
C26 BIAS OUT 0.21524f
C27 SENSE IN2 6.00612f
C28 VX OUT 0.28289f
C29 GP DUMMY 0.00828f
C30 ITAIL VIN 23.4124f
C31 DISABLE KRET 0.52776f
C32 GP OUT 0.17896f
C33 GB DUMMY 0.2077f
C34 VX VDD 0
C35 DI GP 0
C36 GB OUT 0.06508f
C37 VIN BIAS 14.5263f
C38 GP VDD 1.00709f
C39 DI GB 0.16139f
C40 OUT DUMMY 0
C41 BIAS DISABLE 1.26984f
C42 VIN ICTRL 42.5313f
C43 DUMMY VSS 0.75157f
C44 OUT VSS 3.35867f
C45 DATA VSS 0.51379f
C46 KRET VSS 4.89795f
C47 DISABLE VSS 15.0691f
C48 BIAS VSS 59.8071f
C49 ICTRL VSS 41.8607f
C50 IN2 VSS 27.4257f
C51 SENSE VSS 19.665f
C52 VSET VSS 9.3839f
C53 IPB VSS 15.7912f
C54 VDD VSS 9.83972f
C55 VIN VSS 0.96911p
C56 VX VSS 2.63115f ; **FLOATING
C57 GP VSS 2.43017f ; **FLOATING
C58 GB VSS 5.1652f ; **FLOATING
C59 DI VSS 2.35458f ; **FLOATING
C60 IN1 VSS 44.9246f ; **FLOATING
C61 ITAIL VSS 20.9634f ; **FLOATING
