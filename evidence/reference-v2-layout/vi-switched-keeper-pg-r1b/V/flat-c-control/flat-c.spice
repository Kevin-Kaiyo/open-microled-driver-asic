* NGSPICE file created from nrz_vi_reference.ext - technology: gf180mcuD

X0 VSS IN1 IN2 VSS nfet_06v0 ad=22p pd=0.10088m as=22p ps=0.10088m w=50u l=10u
X1 VSS IN1 IN1 VSS nfet_06v0 ad=22p pd=0.10088m as=22p ps=0.10088m w=50u l=10u
X2 VIN ICTRL IOUT VIN pfet_06v0 ad=44p pd=0.20088m as=44p ps=0.20088m w=100u l=10u
X3 VIN ICTRL ICTRL VIN pfet_06v0 ad=44p pd=0.20088m as=44p ps=0.20088m w=100u l=10u
X4 VSS DISABLE IOUT VSS nfet_06v0 ad=4.4p pd=20.88u as=4.4p ps=20.88u w=10u l=0.7u
X5 ITAIL SENSE IN2 VIN pfet_06v0 ad=44p pd=0.20088m as=44p ps=0.20088m w=100u l=10u
X6 VSS IN2 ICTRL VSS nfet_06v0 ad=8.8p pd=40.88u as=8.8p ps=40.88u w=20u l=1u
X7 VIN IPB IPB VIN pfet_06v0 ad=8.8p pd=40.88u as=8.8p ps=40.88u w=20u l=4u
X8 VIN ICTRL SENSE VIN pfet_06v0 ad=44p pd=0.20088m as=44p ps=0.20088m w=100u l=10u
X9 ITAIL VSET IN1 VIN pfet_06v0 ad=44p pd=0.20088m as=44p ps=0.20088m w=100u l=10u
X10 VIN IPB ITAIL VIN pfet_06v0 ad=8.8p pd=40.88u as=8.8p ps=40.88u w=20u l=4u
X11 VSS DISABLE KRET VSS nfet_06v0 ad=0.44p pd=2.88u as=0.44p ps=2.88u w=1u l=0.7u
C0 DISABLE KRET 0.52776f
C1 SENSE IN2 6.00612f
C2 ITAIL VSET 5.60671f
C3 VIN IOUT 14.2834f
C4 ITAIL IPB 1.35408f
C5 IN1 VIN 12.5166f
C6 IOUT DISABLE 1.26984f
C7 VIN ICTRL 42.5313f
C8 ITAIL VIN 23.4124f
C9 VIN IN2 12.0698f
C10 ICTRL IOUT 7.17502f
C11 VIN SENSE 16.1167f
C12 ITAIL IN1 0.69787f
C13 VIN VSET 4.33839f
C14 IN1 IN2 2.95668f
C15 IN2 ICTRL 1.15305f
C16 ITAIL IN2 0.11377f
C17 IN1 SENSE 0.06934f
C18 VIN IPB 12.2128f
C19 SENSE ICTRL 5.76417f
C20 ITAIL SENSE 5.60611f
C21 IN1 VSET 5.60438f
C22 KRET VSS 4.89795f
C23 DISABLE VSS 15.0691f
C24 IOUT VSS 22.3066f
C25 ICTRL VSS 41.8608f
C26 IN2 VSS 27.4257f
C27 SENSE VSS 19.665f
C28 VSET VSS 9.3839f
C29 IPB VSS 15.7912f
C30 VIN VSS 0.96894p
C31 IN1 VSS 44.9246f ; **FLOATING
C32 ITAIL VSS 20.9634f ; **FLOATING
