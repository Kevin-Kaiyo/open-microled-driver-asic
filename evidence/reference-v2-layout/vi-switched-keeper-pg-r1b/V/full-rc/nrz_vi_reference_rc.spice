* Audited RC model assembly from build/reference-v2-layout/vi-switched-keeper-pg-r1b/V/readback/nrz_vi_reference.ext.
* Original Magic RC preserved in ../unmodified-full-rc/.
* R/MOS unchanged; C counted once with post-simplification allocation weights.
* Coupling remains at original logical nodes; no EM claim.
.subckt nrz_vi_reference VIN VSS VSET SENSE IOUT IPB IN2 ICTRL DISABLE KRET
X0 VSS.t9 IN1.t3 IN2.t0 VSS.t8 nfet_06v0 ad=22p pd=0.10088m as=22p ps=0.10088m w=50u l=10u
X1 VSS.t7 IN1.t1 IN1.t2 VSS.t6 nfet_06v0 ad=22p pd=0.10088m as=22p ps=0.10088m w=50u l=10u
X2 VIN.t1 ICTRL.t3 IOUT.t1 VIN.t0 pfet_06v0 ad=44p pd=0.20088m as=44p ps=0.20088m w=100u l=10u
X3 VIN.t3 ICTRL.t0 ICTRL.t1 VIN.t2 pfet_06v0 ad=44p pd=0.20088m as=44p ps=0.20088m w=100u l=10u
X4 VSS.t1 DISABLE.t1 IOUT.t0 VSS.t0 nfet_06v0 ad=4.4p pd=20.88u as=4.4p ps=20.88u w=10u l=0.7u
X5 ITAIL.t0 SENSE.t1 IN2.t1 VIN.t6 pfet_06v0 ad=44p pd=0.20088m as=44p ps=0.20088m w=100u l=10u
X6 VSS.t5 IN2.t2 ICTRL.t2 VSS.t4 nfet_06v0 ad=8.8p pd=40.88u as=8.8p ps=40.88u w=20u l=1u
X7 VIN.t11 IPB.t0 IPB.t1 VIN.t10 pfet_06v0 ad=8.8p pd=40.88u as=8.8p ps=40.88u w=20u l=4u
X8 VIN.t5 ICTRL.t4 SENSE.t0 VIN.t4 pfet_06v0 ad=44p pd=0.20088m as=44p ps=0.20088m w=100u l=10u
X9 ITAIL.t1 VSET.t0 IN1.t0 VIN.t7 pfet_06v0 ad=44p pd=0.20088m as=44p ps=0.20088m w=100u l=10u
X10 VIN.t9 IPB.t2 ITAIL.t2 VIN.t8 pfet_06v0 ad=8.8p pd=40.88u as=8.8p ps=40.88u w=20u l=4u
X11 VSS.t3 DISABLE.t0 KRET.t0 VSS.t2 nfet_06v0 ad=0.44p pd=2.88u as=0.44p ps=2.88u w=1u l=0.7u
R0 KRET KRET.t0 33.1811
R1 DISABLE.n0 DISABLE.t1 105.502
R2 DISABLE.n0 DISABLE.t0 60.4922
R3 DISABLE DISABLE.n0 0.0905
R4 IOUT.n11 IOUT.n10 27.0723
R5 IOUT.n20 IOUT.n19 21.1463
R6 IOUT.n15 IOUT.t1 7.79795
R7 IOUT.n4 IOUT.t0 4.70498
R8 IOUT.n6 IOUT.n5 4.57095
R9 IOUT.n16 IOUT.n15 4.57095
R10 IOUT.n10 IOUT.n9 4.5005
R11 IOUT.n18 IOUT.n17 4.5005
R12 IOUT.n19 IOUT.n18 4.5005
R13 IOUT.n14 IOUT.n13 4.5005
R14 IOUT.n5 IOUT.n4 4.5005
R15 IOUT.n2 IOUT.n1 4.5005
R16 IOUT.n8 IOUT.n7 4.5005
R17 IOUT.n9 IOUT.n8 4.5005
R18 IOUT.n3 IOUT.n2 4.5005
R19 IOUT.n22 IOUT.n11 4.5005
R20 IOUT.n22 IOUT.n0 3.95876
R21 IOUT.n22 IOUT.n21 2.27432
R22 IOUT.n7 IOUT.n6 2.21603
R23 IOUT.n17 IOUT.n16 2.21603
R24 IOUT.n7 IOUT.n0 0.975654
R25 IOUT.n5 IOUT.n2 0.142605
R26 IOUT.n9 IOUT.n2 0.142605
R27 IOUT.n18 IOUT.n14 0.142605
R28 IOUT.n8 IOUT.n3 0.142605
R29 IOUT.n21 IOUT.n20 0.079578
R30 IOUT.n6 IOUT.n3 0.0709482
R31 IOUT.n16 IOUT.n14 0.0709482
R32 IOUT.n20 IOUT.n11 0.068
R33 IOUT.n19 IOUT.n13 0.0545
R34 IOUT.n15 IOUT.n13 0.0545
R35 IOUT.n10 IOUT.n1 0.0458782
R36 IOUT.n4 IOUT.n1 0.0458782
R37 IOUT.n21 IOUT.n12 0.0123666
R38 IOUT.n17 IOUT.n0 0.00877641
R39 IOUT IOUT.n22 0.006125
R40 ICTRL.n0 ICTRL.t3 104.13
R41 ICTRL.n0 ICTRL.t4 99.1807
R42 ICTRL.n1 ICTRL.t0 99.1807
R43 ICTRL.n2 ICTRL.t1 41.0168
R44 ICTRL.n3 ICTRL.t2 31.7324
R45 ICTRL.n1 ICTRL.n0 4.9505
R46 ICTRL.n3 ICTRL.n2 3.038
R47 ICTRL.n2 ICTRL.n1 1.184
R48 ICTRL ICTRL.n3 0.0905
R49 IN2.n0 IN2.t2 130.244
R50 IN2.n1 IN2.t1 41.4905
R51 IN2.n0 IN2.t0 35.619
R52 IN2.n1 IN2.n0 9.9005
R53 IN2 IN2.n1 0.0905
R54 SENSE.n0 SENSE.t1 101.076
R55 SENSE.n0 SENSE.t0 65.578
R56 SENSE SENSE.n0 0.0905
R57 VSET VSET.t0 101.639
R58 IPB.n0 IPB.t2 68.1472
R59 IPB.n0 IPB.t0 64.0972
R60 IPB.n1 IPB.t1 32.6627
R61 IPB.n1 IPB.n0 0.509
R62 IPB IPB.n1 0.0905
R63 VIN.n107 VIN.t8 102.373
R64 VIN.n125 VIN.t10 102.373
R65 VIN.n74 VIN.t2 64.616
R66 VIN.n41 VIN.t0 64.616
R67 VIN.n57 VIN.t4 64.616
R68 VIN.n90 VIN.t7 64.616
R69 VIN.n80 VIN.t6 64.616
R70 VIN.n33 VIN.n23 21.1752
R71 VIN.n87 VIN.n12 18.9005
R72 VIN.n120 VIN.n119 18.3042
R73 VIN.n109 VIN.n1 18.3042
R74 VIN.n54 VIN.n53 18.3042
R75 VIN.n130 VIN.n129 18.3042
R76 VIN.n97 VIN.n96 18.3042
R77 VIN.n43 VIN.n23 18.3042
R78 VIN.n99 VIN.n98 18.3042
R79 VIN.n76 VIN.n12 18.3042
R80 VIN.n66 VIN.n65 18.3042
R81 VIN.n64 VIN.n63 18.3042
R82 VIN.n87 VIN.n86 18.3042
R83 VIN.n21 VIN.t3 9.59795
R84 VIN.n47 VIN.t5 9.59795
R85 VIN.n31 VIN.t1 9.59795
R86 VIN.n113 VIN.t11 6.17014
R87 VIN.n10 VIN.t9 6.17014
R88 VIN.n97 VIN.n87 4.9505
R89 VIN.n115 VIN.n114 4.57095
R90 VIN.n40 VIN.n37 4.57095
R91 VIN.n126 VIN.n125 4.57095
R92 VIN.n9 VIN.n6 4.57095
R93 VIN.n49 VIN.n48 4.57095
R94 VIN.n73 VIN.n70 4.57095
R95 VIN.n92 VIN.n91 4.57095
R96 VIN.n20 VIN.n17 4.57095
R97 VIN.n82 VIN.n81 4.57095
R98 VIN.n59 VIN.n58 4.57095
R99 VIN.n30 VIN.n27 4.57095
R100 VIN.n106 VIN.n103 4.57095
R101 VIN.n107 VIN.n106 4.5005
R102 VIN.n108 VIN.n105 4.5005
R103 VIN.n45 VIN.n44 4.5005
R104 VIN.n39 VIN.n38 4.5005
R105 VIN.n72 VIN.n71 4.5005
R106 VIN.n96 VIN.n95 4.5005
R107 VIN.n77 VIN.n76 4.5005
R108 VIN.n75 VIN.n72 4.5005
R109 VIN.n74 VIN.n73 4.5005
R110 VIN.n128 VIN.n127 4.5005
R111 VIN.n93 VIN.n89 4.5005
R112 VIN.n81 VIN.n80 4.5005
R113 VIN.n85 VIN.n84 4.5005
R114 VIN.n15 VIN.n14 4.5005
R115 VIN.n14 VIN.n13 4.5005
R116 VIN.n86 VIN.n85 4.5005
R117 VIN.n129 VIN.n128 4.5005
R118 VIN.n124 VIN.n123 4.5005
R119 VIN.n132 VIN.n121 4.5005
R120 VIN.n95 VIN.n94 4.5005
R121 VIN.n94 VIN.n5 4.5005
R122 VIN.n117 VIN.n116 4.5005
R123 VIN.n112 VIN.n111 4.5005
R124 VIN.n102 VIN.n101 4.5005
R125 VIN.n84 VIN.n83 4.5005
R126 VIN.n79 VIN.n78 4.5005
R127 VIN.n69 VIN.n68 4.5005
R128 VIN.n61 VIN.n16 4.5005
R129 VIN.n51 VIN.n50 4.5005
R130 VIN.n46 VIN.n45 4.5005
R131 VIN.n36 VIN.n35 4.5005
R132 VIN.n114 VIN.n113 4.5005
R133 VIN.n3 VIN.n2 4.5005
R134 VIN.n119 VIN.n118 4.5005
R135 VIN.n4 VIN.n3 4.5005
R136 VIN.n118 VIN.n117 4.5005
R137 VIN.n35 VIN.n34 4.5005
R138 VIN.n29 VIN.n28 4.5005
R139 VIN.n34 VIN.n33 4.5005
R140 VIN.n32 VIN.n29 4.5005
R141 VIN.n31 VIN.n30 4.5005
R142 VIN.n91 VIN.n90 4.5005
R143 VIN.n41 VIN.n40 4.5005
R144 VIN.n105 VIN.n104 4.5005
R145 VIN.n52 VIN.n51 4.5005
R146 VIN.n26 VIN.n25 4.5005
R147 VIN.n111 VIN.n110 4.5005
R148 VIN.n53 VIN.n52 4.5005
R149 VIN.n25 VIN.n24 4.5005
R150 VIN.n48 VIN.n47 4.5005
R151 VIN.n62 VIN.n61 4.5005
R152 VIN.n60 VIN.n56 4.5005
R153 VIN.n10 VIN.n9 4.5005
R154 VIN.n63 VIN.n62 4.5005
R155 VIN.n56 VIN.n55 4.5005
R156 VIN.n58 VIN.n57 4.5005
R157 VIN.n11 VIN.n8 4.5005
R158 VIN.n100 VIN.n99 4.5005
R159 VIN.n68 VIN.n67 4.5005
R160 VIN.n19 VIN.n18 4.5005
R161 VIN.n8 VIN.n7 4.5005
R162 VIN.n67 VIN.n66 4.5005
R163 VIN.n22 VIN.n19 4.5005
R164 VIN.n21 VIN.n20 4.5005
R165 VIN.n89 VIN.n88 4.5005
R166 VIN.n101 VIN.n100 4.5005
R167 VIN.n42 VIN.n39 4.5005
R168 VIN.n110 VIN.n109 4.5005
R169 VIN.n44 VIN.n43 4.5005
R170 VIN.n78 VIN.n77 4.5005
R171 VIN.n132 VIN.n0 3.28376
R172 VIN.n65 VIN.n12 2.8715
R173 VIN.n64 VIN.n54 2.8715
R174 VIN.n120 VIN.n1 2.5295
R175 VIN.n132 VIN.n131 2.27432
R176 VIN.n83 VIN.n82 2.21603
R177 VIN.n69 VIN.n17 2.21603
R178 VIN.n102 VIN.n6 2.21603
R179 VIN.n36 VIN.n27 2.21603
R180 VIN.n46 VIN.n37 2.21603
R181 VIN.n50 VIN.n49 2.21603
R182 VIN.n59 VIN.n16 2.21603
R183 VIN.n112 VIN.n103 2.21603
R184 VIN.n92 VIN.n5 2.21603
R185 VIN.n116 VIN.n115 2.21603
R186 VIN.n127 VIN.n126 2.21603
R187 VIN.n79 VIN.n70 2.21603
R188 VIN.n54 VIN.n23 2.0795
R189 VIN.n65 VIN.n64 2.0795
R190 VIN.n98 VIN.n97 1.8545
R191 VIN.n98 VIN.n1 1.5215
R192 VIN.n121 VIN.n120 1.454
R193 VIN.n116 VIN.n0 0.847054
R194 VIN.n83 VIN.n79 0.5605
R195 VIN.n83 VIN.n5 0.147167
R196 VIN.n128 VIN.n124 0.142605
R197 VIN.n35 VIN.n28 0.142605
R198 VIN.n34 VIN.n29 0.142605
R199 VIN.n30 VIN.n29 0.142605
R200 VIN.n45 VIN.n38 0.142605
R201 VIN.n44 VIN.n39 0.142605
R202 VIN.n40 VIN.n39 0.142605
R203 VIN.n51 VIN.n26 0.142605
R204 VIN.n52 VIN.n25 0.142605
R205 VIN.n48 VIN.n25 0.142605
R206 VIN.n62 VIN.n56 0.142605
R207 VIN.n58 VIN.n56 0.142605
R208 VIN.n68 VIN.n18 0.142605
R209 VIN.n67 VIN.n19 0.142605
R210 VIN.n20 VIN.n19 0.142605
R211 VIN.n78 VIN.n71 0.142605
R212 VIN.n77 VIN.n72 0.142605
R213 VIN.n73 VIN.n72 0.142605
R214 VIN.n84 VIN.n15 0.142605
R215 VIN.n85 VIN.n14 0.142605
R216 VIN.n81 VIN.n14 0.142605
R217 VIN.n101 VIN.n7 0.142605
R218 VIN.n100 VIN.n8 0.142605
R219 VIN.n9 VIN.n8 0.142605
R220 VIN.n111 VIN.n104 0.142605
R221 VIN.n110 VIN.n105 0.142605
R222 VIN.n106 VIN.n105 0.142605
R223 VIN.n117 VIN.n4 0.142605
R224 VIN.n118 VIN.n3 0.142605
R225 VIN.n114 VIN.n3 0.142605
R226 VIN.n94 VIN.n93 0.142605
R227 VIN.n95 VIN.n89 0.142605
R228 VIN.n91 VIN.n89 0.142605
R229 VIN.n61 VIN.n60 0.142605
R230 VIN.n79 VIN.n69 0.0855667
R231 VIN.n50 VIN.n16 0.0855667
R232 VIN.n46 VIN.n36 0.0855667
R233 VIN.n131 VIN.n130 0.079578
R234 VIN.n116 VIN.n112 0.0754333
R235 VIN.n115 VIN.n4 0.0709482
R236 VIN.n18 VIN.n17 0.0709482
R237 VIN.n28 VIN.n27 0.0709482
R238 VIN.n7 VIN.n6 0.0709482
R239 VIN.n38 VIN.n37 0.0709482
R240 VIN.n71 VIN.n70 0.0709482
R241 VIN.n93 VIN.n92 0.0709482
R242 VIN.n104 VIN.n103 0.0709482
R243 VIN.n60 VIN.n59 0.0709482
R244 VIN.n82 VIN.n15 0.0709482
R245 VIN.n49 VIN.n26 0.0709482
R246 VIN.n126 VIN.n124 0.0709482
R247 VIN.n130 VIN.n121 0.068
R248 VIN.n50 VIN.n46 0.0621
R249 VIN.n69 VIN.n16 0.0621
R250 VIN.n102 VIN.n5 0.0554333
R251 VIN.n99 VIN.n11 0.0545
R252 VIN.n11 VIN.n10 0.0545
R253 VIN.n47 VIN.n24 0.0545
R254 VIN.n53 VIN.n24 0.0545
R255 VIN.n42 VIN.n41 0.0545
R256 VIN.n43 VIN.n42 0.0545
R257 VIN.n32 VIN.n31 0.0545
R258 VIN.n33 VIN.n32 0.0545
R259 VIN.n109 VIN.n108 0.0545
R260 VIN.n108 VIN.n107 0.0545
R261 VIN.n96 VIN.n88 0.0545
R262 VIN.n90 VIN.n88 0.0545
R263 VIN.n119 VIN.n2 0.0545
R264 VIN.n113 VIN.n2 0.0545
R265 VIN.n22 VIN.n21 0.0545
R266 VIN.n66 VIN.n22 0.0545
R267 VIN.n57 VIN.n55 0.0545
R268 VIN.n125 VIN.n123 0.0545
R269 VIN.n75 VIN.n74 0.0545
R270 VIN.n63 VIN.n55 0.0545
R271 VIN.n129 VIN.n123 0.0545
R272 VIN.n76 VIN.n75 0.0545
R273 VIN.n86 VIN.n13 0.0545
R274 VIN.n80 VIN.n13 0.0545
R275 VIN.n112 VIN.n102 0.0455667
R276 VIN.n131 VIN.n122 0.0123666
R277 VIN.n127 VIN.n0 0.00877641
R278 VIN VIN.n132 0.006125
R279 VSS.n61 VSS.n7 3666.31
R280 VSS.n121 VSS.n6 621.611
R281 VSS.n81 VSS.n9 621.444
R282 VSS.n118 VSS.n9 621.444
R283 VSS.n81 VSS.n8 621.444
R284 VSS.n6 VSS.n5 621.444
R285 VSS.n122 VSS.n5 621.444
R286 VSS.n118 VSS.n8 621.444
R287 VSS.n83 VSS.n82 458.818
R288 VSS.n61 VSS.n60 456.721
R289 VSS.n120 VSS.n119 316.796
R290 VSS.n82 VSS.t8 188.69
R291 VSS.t6 VSS.n120 188.69
R292 VSS.n122 VSS.n121 144.732
R293 VSS.n63 VSS.n28 143.136
R294 VSS.n28 VSS.n27 142.139
R295 VSS.n64 VSS.n27 142.139
R296 VSS.n119 VSS.n7 125.584
R297 VSS.t8 VSS.n7 63.1073
R298 VSS.t0 VSS.n62 41.9665
R299 VSS.n83 VSS.t4 33.7241
R300 VSS.n64 VSS.n63 32.2971
R301 VSS.n62 VSS.n61 27.9253
R302 VSS.n54 VSS.n53 21.1209
R303 VSS.n128 VSS.n127 20.1989
R304 VSS.n109 VSS.n108 20.1989
R305 VSS.n98 VSS.n97 20.1989
R306 VSS.n111 VSS.n110 20.1989
R307 VSS.n74 VSS.n73 20.1989
R308 VSS.n87 VSS.n13 20.1989
R309 VSS.n72 VSS.n71 20.1989
R310 VSS.n55 VSS.n54 20.1989
R311 VSS.n42 VSS.n24 20.1962
R312 VSS.n73 VSS.n72 17.942
R313 VSS.n60 VSS.t2 16.5372
R314 VSS.n47 VSS.t3 12.6452
R315 VSS.n60 VSS.n59 9.15575
R316 VSS.n102 VSS.t7 6.49753
R317 VSS.n91 VSS.t9 6.49753
R318 VSS.n118 VSS.n117 6.42734
R319 VSS.n123 VSS.n122 6.42734
R320 VSS.n40 VSS.t1 5.82998
R321 VSS.n85 VSS.n83 5.33341
R322 VSS.n22 VSS.t5 5.28723
R323 VSS.n65 VSS.n64 4.90478
R324 VSS.n67 VSS.n66 4.57095
R325 VSS.n56 VSS.n32 4.57095
R326 VSS.n84 VSS.n78 4.57095
R327 VSS.n124 VSS.n123 4.57095
R328 VSS.n104 VSS.n103 4.57095
R329 VSS.n93 VSS.n92 4.57095
R330 VSS.n49 VSS.n48 4.57095
R331 VSS.n116 VSS.n115 4.57095
R332 VSS.n39 VSS.n36 4.57095
R333 VSS.n21 VSS.n18 4.57095
R334 VSS.n96 VSS.n95 4.5005
R335 VSS.n75 VSS.n74 4.5005
R336 VSS.n23 VSS.n20 4.5005
R337 VSS.n22 VSS.n21 4.5005
R338 VSS.n126 VSS.n125 4.5005
R339 VSS.n85 VSS.n84 4.5005
R340 VSS.n89 VSS.n88 4.5005
R341 VSS.n80 VSS.n79 4.5005
R342 VSS.n86 VSS.n80 4.5005
R343 VSS.n88 VSS.n87 4.5005
R344 VSS.n127 VSS.n126 4.5005
R345 VSS.n4 VSS.n3 4.5005
R346 VSS.n130 VSS.n1 4.5005
R347 VSS.n103 VSS.n102 4.5005
R348 VSS.n100 VSS.n99 4.5005
R349 VSS.n108 VSS.n107 4.5005
R350 VSS.n56 VSS.n55 4.5005
R351 VSS.n57 VSS.n29 4.5005
R352 VSS.n59 VSS.n58 4.5005
R353 VSS.n101 VSS.n100 4.5005
R354 VSS.n58 VSS.n30 4.5005
R355 VSS.n57 VSS.n31 4.5005
R356 VSS.n46 VSS.n30 4.5005
R357 VSS.n107 VSS.n106 4.5005
R358 VSS.n106 VSS.n105 4.5005
R359 VSS.n113 VSS.n12 4.5005
R360 VSS.n95 VSS.n94 4.5005
R361 VSS.n90 VSS.n89 4.5005
R362 VSS.n77 VSS.n76 4.5005
R363 VSS.n69 VSS.n17 4.5005
R364 VSS.n45 VSS.n44 4.5005
R365 VSS.n51 VSS.n50 4.5005
R366 VSS.n117 VSS.n116 4.5005
R367 VSS.n11 VSS.n10 4.5005
R368 VSS.n112 VSS.n111 4.5005
R369 VSS.n114 VSS.n11 4.5005
R370 VSS.n52 VSS.n51 4.5005
R371 VSS.n35 VSS.n34 4.5005
R372 VSS.n53 VSS.n52 4.5005
R373 VSS.n34 VSS.n33 4.5005
R374 VSS.n48 VSS.n47 4.5005
R375 VSS.n113 VSS.n112 4.5005
R376 VSS.n44 VSS.n43 4.5005
R377 VSS.n38 VSS.n37 4.5005
R378 VSS.n43 VSS.n42 4.5005
R379 VSS.n41 VSS.n38 4.5005
R380 VSS.n40 VSS.n39 4.5005
R381 VSS.n92 VSS.n91 4.5005
R382 VSS.n15 VSS.n14 4.5005
R383 VSS.n70 VSS.n69 4.5005
R384 VSS.n68 VSS.n26 4.5005
R385 VSS.n97 VSS.n96 4.5005
R386 VSS.n71 VSS.n70 4.5005
R387 VSS.n26 VSS.n25 4.5005
R388 VSS.n66 VSS.n65 4.5005
R389 VSS.n16 VSS.n15 4.5005
R390 VSS.n76 VSS.n75 4.5005
R391 VSS.n20 VSS.n19 4.5005
R392 VSS.n130 VSS.n0 3.73376
R393 VSS.n54 VSS.n24 3.12575
R394 VSS.n98 VSS.n13 2.9795
R395 VSS.n110 VSS.n98 2.8715
R396 VSS.n109 VSS.n1 2.804
R397 VSS.n130 VSS.n129 2.27432
R398 VSS.n50 VSS.n49 2.21603
R399 VSS.n45 VSS.n36 2.21603
R400 VSS.n125 VSS.n124 2.21603
R401 VSS.n67 VSS.n17 2.21603
R402 VSS.n77 VSS.n18 2.21603
R403 VSS.n90 VSS.n78 2.21603
R404 VSS.n94 VSS.n93 2.21603
R405 VSS.n115 VSS.n12 2.21603
R406 VSS.n105 VSS.n104 2.21603
R407 VSS.n46 VSS.n32 2.21603
R408 VSS.n110 VSS.n109 2.0795
R409 VSS.t0 VSS.n27 1.3005
R410 VSS.n73 VSS.n13 0.959
R411 VSS.n72 VSS.n24 0.92525
R412 VSS.n105 VSS.n0 0.887054
R413 VSS.n77 VSS.n17 0.5321
R414 VSS.n63 VSS.t0 0.296379
R415 VSS.t8 VSS.n9 0.217167
R416 VSS.t8 VSS.n8 0.217167
R417 VSS.t6 VSS.n5 0.217167
R418 VSS.n62 VSS.n28 0.2085
R419 VSS.n126 VSS.n4 0.142605
R420 VSS.n57 VSS.n56 0.142605
R421 VSS.n58 VSS.n57 0.142605
R422 VSS.n31 VSS.n30 0.142605
R423 VSS.n51 VSS.n35 0.142605
R424 VSS.n52 VSS.n34 0.142605
R425 VSS.n48 VSS.n34 0.142605
R426 VSS.n44 VSS.n37 0.142605
R427 VSS.n43 VSS.n38 0.142605
R428 VSS.n39 VSS.n38 0.142605
R429 VSS.n69 VSS.n68 0.142605
R430 VSS.n70 VSS.n26 0.142605
R431 VSS.n66 VSS.n26 0.142605
R432 VSS.n76 VSS.n19 0.142605
R433 VSS.n75 VSS.n20 0.142605
R434 VSS.n21 VSS.n20 0.142605
R435 VSS.n89 VSS.n79 0.142605
R436 VSS.n88 VSS.n80 0.142605
R437 VSS.n84 VSS.n80 0.142605
R438 VSS.n95 VSS.n16 0.142605
R439 VSS.n96 VSS.n15 0.142605
R440 VSS.n92 VSS.n15 0.142605
R441 VSS.n114 VSS.n113 0.142605
R442 VSS.n112 VSS.n11 0.142605
R443 VSS.n106 VSS.n101 0.142605
R444 VSS.n107 VSS.n100 0.142605
R445 VSS.n103 VSS.n100 0.142605
R446 VSS.n116 VSS.n11 0.142605
R447 VSS.n46 VSS.n45 0.0891
R448 VSS.n94 VSS.n90 0.0887667
R449 VSS.n94 VSS.n12 0.0855667
R450 VSS.n129 VSS.n128 0.079578
R451 VSS.n79 VSS.n78 0.0709482
R452 VSS.n93 VSS.n16 0.0709482
R453 VSS.n124 VSS.n4 0.0709482
R454 VSS.n68 VSS.n67 0.0709482
R455 VSS.n115 VSS.n114 0.0709482
R456 VSS.n19 VSS.n18 0.0709482
R457 VSS.n37 VSS.n36 0.0709482
R458 VSS.n49 VSS.n35 0.0709482
R459 VSS.n104 VSS.n101 0.0709482
R460 VSS.n32 VSS.n31 0.0709482
R461 VSS.n128 VSS.n1 0.068
R462 VSS.n105 VSS.n12 0.0621
R463 VSS.n127 VSS.n3 0.0545
R464 VSS.n97 VSS.n14 0.0545
R465 VSS.n91 VSS.n14 0.0545
R466 VSS.n111 VSS.n10 0.0545
R467 VSS.n117 VSS.n10 0.0545
R468 VSS.n59 VSS.n29 0.0545
R469 VSS.n55 VSS.n29 0.0545
R470 VSS.n108 VSS.n99 0.0545
R471 VSS.n23 VSS.n22 0.0545
R472 VSS.n102 VSS.n99 0.0545
R473 VSS.n87 VSS.n86 0.0545
R474 VSS.n86 VSS.n85 0.0545
R475 VSS.n74 VSS.n23 0.0545
R476 VSS.n65 VSS.n25 0.0545
R477 VSS.n71 VSS.n25 0.0545
R478 VSS.n123 VSS.n3 0.0545
R479 VSS.n121 VSS.t6 0.0514603
R480 VSS.n120 VSS.n6 0.0477727
R481 VSS.n119 VSS.n118 0.0477727
R482 VSS.n82 VSS.n81 0.0477727
R483 VSS.n47 VSS.n33 0.0458782
R484 VSS.n41 VSS.n40 0.0458782
R485 VSS.n42 VSS.n41 0.0458782
R486 VSS.n53 VSS.n33 0.0458782
R487 VSS.n45 VSS.n17 0.0319
R488 VSS.n50 VSS.n46 0.0319
R489 VSS.n90 VSS.n77 0.0289
R490 VSS.n129 VSS.n2 0.0123666
R491 VSS.n125 VSS.n0 0.00877641
R492 VSS VSS.n130 0.006125
R493 IN1.n0 IN1.t3 72.1438
R494 IN1.n0 IN1.t1 67.1938
R495 IN1.n4 IN1.n3 39.1039
R496 IN1.n1 IN1.t2 33.2506
R497 IN1.n4 IN1.n1 9.9005
R498 IN1.n1 IN1.n0 1.184
R499 IN1 IN1.n4 0.068
R500 IN1.n3 IN1.t0 0.0187
R501 IN1.n3 IN1.n2 0.0131
R502 ITAIL.n0 ITAIL.t0 44.5457
R503 ITAIL.n0 ITAIL.t1 39.5957
R504 ITAIL.n3 ITAIL.n2 30.2033
R505 ITAIL.n3 ITAIL.n0 5.7425
R506 ITAIL.n2 ITAIL.t2 0.0915
R507 ITAIL ITAIL.n3 0.068
R508 ITAIL.n2 ITAIL.n1 0.0635
C0 DISABLE VSS 2.0889683081542602e-17
C1 DISABLE.n0 VSS 1.0741847677186728e-14
C2 DISABLE.t0 VSS 2.1323414312085483e-15
C3 DISABLE.t1 VSS 2.1740212085231821e-15
C4 ICTRL VSS 1.451239465617842e-18
C5 ICTRL.n0 VSS 3.6379680741768487e-15
C6 ICTRL.n1 VSS 1.8475609695724581e-15
C7 ICTRL.n2 VSS 3.572297684510396e-16
C8 ICTRL.n3 VSS 2.5499007229758112e-16
C9 ICTRL.t0 VSS 1.1391147496752974e-14
C10 ICTRL.t1 VSS 1.121201955105691e-15
C11 ICTRL.t2 VSS 3.7964626688024336e-16
C12 ICTRL.t3 VSS 1.1478456660544578e-14
C13 ICTRL.t4 VSS 1.1391147496752974e-14
C14 IN1 VSS 4.6547264064003637e-18
C15 IN1.n0 VSS 4.8840704826937861e-15
C16 IN1.n1 VSS 9.7767372551912539e-16
C17 IN1.n2 VSS 2.992331463145452e-16
C18 IN1.n3 VSS 2.3016051817190565e-15
C19 IN1.n4 VSS 1.1002366641387368e-15
C20 IN1.t0 VSS 4.3222474177493821e-16
C21 IN1.t1 VSS 1.6496732569569281e-14
C22 IN1.t2 VSS 1.7589345681961068e-15
C23 IN1.t3 VSS 1.6669234193668027e-14
C24 IN2 VSS 1.1442248640874285e-17
C25 IN2.n0 VSS 7.4655300249214701e-15
C26 IN2.n1 VSS 3.3417296039139942e-15
C27 IN2.t0 VSS 5.2257886152296377e-15
C28 IN2.t1 VSS 8.876378940804117e-15
C29 IN2.t2 VSS 2.5048305664899094e-15
C30 IOUT VSS 8.9787817617302734e-18
C31 IOUT.n0 VSS 3.3385799579450922e-15
C32 IOUT.n1 VSS 2.8619890788296714e-17
C33 IOUT.n10 VSS 8.1291917812808006e-16
C34 IOUT.n11 VSS 7.1568227255073166e-16
C35 IOUT.n12 VSS 1.1222262660950105e-17
C36 IOUT.n13 VSS 2.4050271486069773e-17
C37 IOUT.n14 VSS 9.1391110162860721e-18
C38 IOUT.n15 VSS 1.6997295714679429e-15
C39 IOUT.n16 VSS 7.3485681127659251e-18
C40 IOUT.n17 VSS 4.1687176500418726e-17
C41 IOUT.n18 VSS 7.4636133822262004e-18
C42 IOUT.n19 VSS 6.683274333470269e-16
C43 IOUT.n2 VSS 9.1391110162860721e-18
C44 IOUT.n20 VSS 4.2891608804476475e-16
C45 IOUT.n21 VSS 2.7372078507186027e-18
C46 IOUT.n22 VSS 2.2606267860776286e-15
C47 IOUT.n3 VSS 9.1391110162860721e-18
C48 IOUT.n4 VSS 5.985455385859364e-16
C49 IOUT.n5 VSS 7.5786488372120285e-18
C50 IOUT.n6 VSS 7.3485681127659251e-18
C51 IOUT.n7 VSS 7.2686782907725251e-15
C52 IOUT.n8 VSS 7.4636133822262004e-18
C53 IOUT.n9 VSS 7.4636133822262004e-18
C54 IOUT.t0 VSS 5.0438154495774451e-16
C55 IOUT.t1 VSS 3.8208337888160652e-15
C56 IPB VSS 5.9481529904332222e-18
C57 IPB.n0 VSS 3.9655594817821573e-15
C58 IPB.n1 VSS 9.7084961832342254e-16
C59 IPB.t0 VSS 4.5667753501244835e-15
C60 IPB.t1 VSS 1.5942294511304933e-15
C61 IPB.t2 VSS 4.6878379456490129e-15
C62 ITAIL VSS 9.8071468062571662e-18
C63 ITAIL.n0 VSS 4.2135358165408428e-15
C64 ITAIL.n1 VSS 1.2609245730769175e-16
C65 ITAIL.n2 VSS 1.8175438008435657e-15
C66 ITAIL.n3 VSS 1.5575788551739724e-15
C67 ITAIL.t0 VSS 6.6422000880348383e-15
C68 ITAIL.t1 VSS 6.414508539092244e-15
C69 ITAIL.t2 VSS 1.8213329620058983e-16
C70 KRET VSS 2.7675567364080952e-15
C71 KRET.t0 VSS 2.1303932635919043e-15
C72 SENSE VSS 1.8810642236125377e-18
C73 SENSE.n0 VSS 3.1170098362838271e-15
C74 SENSE.t0 VSS 1.7353276386880428e-15
C75 SENSE.t1 VSS 1.4810781460804515e-14
C76 VIN VSS 2.0902414257406077e-17
C77 VIN.n0 VSS 5.3043867844876751e-15
C78 VIN.n1 VSS 1.1203025351901534e-15
C79 VIN.n10 VSS 3.0250543540279148e-15
C80 VIN.n100 VSS 1.7375088243545146e-17
C81 VIN.n101 VSS 1.7375088243545146e-17
C82 VIN.n102 VSS 4.1991452808698222e-15
C83 VIN.n103 VSS 1.7107273924524357e-17
C84 VIN.n104 VSS 2.1275662845178214e-17
C85 VIN.n105 VSS 2.1275662845178214e-17
C86 VIN.n106 VSS 1.7642902562565939e-17
C87 VIN.n107 VSS 1.1597980995004828e-14
C88 VIN.n108 VSS 5.5988556759962719e-17
C89 VIN.n109 VSS 1.3321859480070232e-15
C90 VIN.n11 VSS 5.5988556759962719e-17
C91 VIN.n110 VSS 1.7375088243545146e-17
C92 VIN.n111 VSS 1.7375088243545146e-17
C93 VIN.n112 VSS 5.0389686988475974e-15
C94 VIN.n113 VSS 3.0250543540279148e-15
C95 VIN.n114 VSS 1.7642902562565939e-17
C96 VIN.n115 VSS 1.7107273924524357e-17
C97 VIN.n116 VSS 9.6635158822462337e-15
C98 VIN.n117 VSS 1.7375088243545146e-17
C99 VIN.n118 VSS 1.7375088243545146e-17
C100 VIN.n119 VSS 1.3321859480070232e-15
C101 VIN.n12 VSS 2.5901873296452872e-15
C102 VIN.n120 VSS 1.1146995777264289e-15
C103 VIN.n121 VSS 1.2616098271998075e-16
C104 VIN.n122 VSS 2.6125145865573361e-17
C105 VIN.n123 VSS 5.5988556759962719e-17
C106 VIN.n124 VSS 2.1275662845178214e-17
C107 VIN.n125 VSS 1.1598262904814323e-14
C108 VIN.n126 VSS 1.7107273924524357e-17
C109 VIN.n127 VSS 9.7046747144325865e-17
C110 VIN.n128 VSS 1.7375088243545146e-17
C111 VIN.n129 VSS 1.3321859480070232e-15
C112 VIN.n13 VSS 5.5988556759962719e-17
C113 VIN.n130 VSS 7.9666302614400299e-16
C114 VIN.n131 VSS 6.3721554266783294e-18
C115 VIN.n132 VSS 4.3672269570363185e-15
C116 VIN.n14 VSS 2.1275662845178214e-17
C117 VIN.n15 VSS 2.1275662845178214e-17
C118 VIN.n16 VSS 6.1587426531449461e-15
C119 VIN.n17 VSS 1.7107273924524357e-17
C120 VIN.n18 VSS 2.1275662845178214e-17
C121 VIN.n19 VSS 2.1275662845178214e-17
C122 VIN.n2 VSS 5.5988556759962719e-17
C123 VIN.n20 VSS 1.7642902562565939e-17
C124 VIN.n21 VSS 4.9111155524961192e-15
C125 VIN.n22 VSS 5.5988556759962719e-17
C126 VIN.n23 VSS 2.0949563673044216e-15
C127 VIN.n24 VSS 5.5988556759962719e-17
C128 VIN.n25 VSS 2.1275662845178214e-17
C129 VIN.n26 VSS 2.1275662845178214e-17
C130 VIN.n27 VSS 1.7107273924524357e-17
C131 VIN.n28 VSS 2.1275662845178214e-17
C132 VIN.n29 VSS 2.1275662845178214e-17
C133 VIN.n3 VSS 2.1275662845178214e-17
C134 VIN.n30 VSS 1.7642902562565939e-17
C135 VIN.n31 VSS 4.9111155524961192e-15
C136 VIN.n32 VSS 5.5988556759962719e-17
C137 VIN.n33 VSS 1.4733522851119293e-15
C138 VIN.n34 VSS 1.7375088243545146e-17
C139 VIN.n35 VSS 1.7375088243545146e-17
C140 VIN.n36 VSS 4.4118955663508909e-15
C141 VIN.n37 VSS 1.7107273924524357e-17
C142 VIN.n38 VSS 2.1275662845178214e-17
C143 VIN.n39 VSS 2.1275662845178214e-17
C144 VIN.n4 VSS 2.1275662845178214e-17
C145 VIN.n40 VSS 1.7642902562565939e-17
C146 VIN.n41 VSS 4.2291898188168129e-14
C147 VIN.n42 VSS 5.5988556759962719e-17
C148 VIN.n43 VSS 1.3321859480070232e-15
C149 VIN.n44 VSS 1.7375088243545146e-17
C150 VIN.n45 VSS 1.7375088243545146e-17
C151 VIN.n46 VSS 6.1587426531449461e-15
C152 VIN.n47 VSS 4.9111155524961192e-15
C153 VIN.n48 VSS 1.7642902562565939e-17
C154 VIN.n49 VSS 1.7107273924524357e-17
C155 VIN.n5 VSS 8.4654696693424394e-15
C156 VIN.n50 VSS 6.1587426531449461e-15
C157 VIN.n51 VSS 1.7375088243545146e-17
C158 VIN.n52 VSS 1.7375088243545146e-17
C159 VIN.n53 VSS 1.3321859480070232e-15
C160 VIN.n54 VSS 1.19495225274458e-15
C161 VIN.n55 VSS 5.5988556759962719e-17
C162 VIN.n56 VSS 2.1275662845178214e-17
C163 VIN.n57 VSS 4.2291898188168129e-14
C164 VIN.n58 VSS 1.7642902562565939e-17
C165 VIN.n59 VSS 1.7107273924524357e-17
C166 VIN.n6 VSS 1.7107273924524357e-17
C167 VIN.n60 VSS 2.1275662845178214e-17
C168 VIN.n61 VSS 1.7375088243545146e-17
C169 VIN.n62 VSS 1.7375088243545146e-17
C170 VIN.n63 VSS 1.3321859480070232e-15
C171 VIN.n64 VSS 1.19495225274458e-15
C172 VIN.n65 VSS 1.19495225274458e-15
C173 VIN.n66 VSS 1.3321859480070232e-15
C174 VIN.n67 VSS 1.7375088243545146e-17
C175 VIN.n68 VSS 1.7375088243545146e-17
C176 VIN.n69 VSS 6.1587426531449461e-15
C177 VIN.n7 VSS 2.1275662845178214e-17
C178 VIN.n70 VSS 1.7107273924524357e-17
C179 VIN.n71 VSS 2.1275662845178214e-17
C180 VIN.n72 VSS 2.1275662845178214e-17
C181 VIN.n73 VSS 1.7642902562565939e-17
C182 VIN.n74 VSS 4.2291898188168129e-14
C183 VIN.n75 VSS 5.5988556759962719e-17
C184 VIN.n76 VSS 1.3321859480070232e-15
C185 VIN.n77 VSS 1.7375088243545146e-17
C186 VIN.n78 VSS 1.7375088243545146e-17
C187 VIN.n79 VSS 2.7087304045381742e-14
C188 VIN.n8 VSS 2.1275662845178214e-17
C189 VIN.n80 VSS 4.2291898188168129e-14
C190 VIN.n81 VSS 1.7642902562565939e-17
C191 VIN.n82 VSS 1.7107273924524357e-17
C192 VIN.n83 VSS 2.9673967502408333e-14
C193 VIN.n84 VSS 1.7375088243545146e-17
C194 VIN.n85 VSS 1.7375088243545146e-17
C195 VIN.n86 VSS 1.3321859480070232e-15
C196 VIN.n87 VSS 2.7626315601137267e-15
C197 VIN.n88 VSS 5.5988556759962719e-17
C198 VIN.n89 VSS 2.1275662845178214e-17
C199 VIN.n9 VSS 1.7642902562565939e-17
C200 VIN.n90 VSS 4.2291898188168129e-14
C201 VIN.n91 VSS 1.7642902562565939e-17
C202 VIN.n92 VSS 1.7107273924524357e-17
C203 VIN.n93 VSS 2.1275662845178214e-17
C204 VIN.n94 VSS 1.7375088243545146e-17
C205 VIN.n95 VSS 1.7375088243545146e-17
C206 VIN.n96 VSS 1.3321859480070232e-15
C207 VIN.n97 VSS 1.348734053824413e-15
C208 VIN.n98 VSS 1.0643152470243334e-15
C209 VIN.n99 VSS 1.3321859480070232e-15
C210 VIN.t0 VSS 9.9920817652133188e-14
C211 VIN.t1 VSS 9.806655588017609e-15
C212 VIN.t10 VSS 1.043320013962151e-14
C213 VIN.t11 VSS 2.9584813525155359e-15
C214 VIN.t2 VSS 9.9920817652133188e-14
C215 VIN.t3 VSS 9.806655588017609e-15
C216 VIN.t4 VSS 9.9920817652133188e-14
C217 VIN.t5 VSS 9.806655588017609e-15
C218 VIN.t6 VSS 9.9920817652133188e-14
C219 VIN.t7 VSS 9.9920817652133188e-14
C220 VIN.t8 VSS 1.043320013962151e-14
C221 VIN.t9 VSS 2.9584813525155359e-15
C222 VSET VSS 1.2679285545975405e-15
C223 VSET.t0 VSS 8.1159714454024592e-15
C224 ICTRL IOUT 7.1750200000000012e-15
C225 ITAIL IN2 1.13766e-16
C226 IPB ITAIL 1.3540800000000001e-15
C227 VIN VSET 4.3383900000000007e-15
C228 IN1 SENSE 6.9340500000000005e-17
C229 VIN IN1 1.2516600000000001e-14
C230 IOUT DISABLE 1.2698399999999999e-15
C231 IN1 IN2 2.9566800000000002e-15
C232 ITAIL VSET 5.6067100000000007e-15
C233 VIN SENSE 1.6116700000000003e-14
C234 ICTRL SENSE 5.7641700000000007e-15
C235 SENSE IN2 6.0061200000000007e-15
C236 ITAIL IN1 6.9786699999999999e-16
C237 VIN IN2 1.2069800000000001e-14
C238 ICTRL VIN 4.2531300000000009e-14
C239 VIN IPB 1.22128e-14
C240 DISABLE KRET 5.27759e-16
C241 ICTRL IN2 1.1530500000000001e-15
C242 IOUT VIN 1.42834e-14
C243 ITAIL SENSE 5.6061099999999999e-15
C244 VSET IN1 5.6043800000000006e-15
C245 VIN ITAIL 2.3412400000000005e-14
.ends nrz_vi_reference
