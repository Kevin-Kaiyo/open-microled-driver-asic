* Explicit control derived from full raw RC; original RC retained.
.subckt nrz_vi_reference VIN VSS VSET SENSE IOUT IPB IN2 ICTRL DISABLE KRET
X0 VSS IN1 IN2 VSS nfet_06v0 ad=22p pd=0.10088m as=22p ps=0.10088m w=50u l=10u
X1 VSS IN1 IN1 VSS nfet_06v0 ad=22p pd=0.10088m as=22p ps=0.10088m w=50u l=10u
X2 VIN ICTRL IOUT VIN pfet_06v0 ad=44p pd=0.20088m as=44p ps=0.20088m w=100u l=10u
X3 VIN ICTRL ICTRL VIN pfet_06v0 ad=44p pd=0.20088m as=44p ps=0.20088m w=100u l=10u
X4 VSS DISABLE IOUT VSS nfet_06v0 ad=4.4p pd=20.88u as=4.4p ps=20.88u w=10u l=0.7u
X5 ITAIL SENSE IN2 VIN pfet_06v0 ad=44p pd=0.20088m as=44p ps=0.20088m w=100u l=10u
X6 VSS IN2 ICTRL VSS nfet_06v0 ad=8.8p pd=40.88u as=8.8p ps=40.88u w=20u l=1u
X7 VIN IPB IPB VIN pfet_06v0 ad=8.8p pd=40.88u as=8.8p ps=40.88u w=20u l=4u
X8 VIN ICTRL SENSE VIN pfet_06v0 ad=44p pd=0.20088m as=44p ps=0.20088m w=100u l=10u
X9 ITAIL VSET IN1 VIN pfet_06v0 ad=44p pd=0.20088m as=44p ps=0.20088m w=100u l=10u
X10 VIN IPB ITAIL VIN pfet_06v0 ad=8.8p pd=40.88u as=8.8p ps=40.88u w=20u l=4u
X11 VSS DISABLE KRET VSS nfet_06v0 ad=0.44p pd=2.88u as=0.44p ps=2.88u w=1u l=0.7u
C0 DISABLE VSS 2.08896830815e-17
C1 DISABLE VSS 1.07418476772e-14
C2 DISABLE VSS 2.13234143121e-15
C3 DISABLE VSS 2.17402120852e-15
C4 ICTRL VSS 1.45123946562e-18
C5 ICTRL VSS 3.63796807418e-15
C6 ICTRL VSS 1.84756096957e-15
C7 ICTRL VSS 3.57229768451e-16
C8 ICTRL VSS 2.54990072298e-16
C9 ICTRL VSS 1.13911474968e-14
C10 ICTRL VSS 1.12120195511e-15
C11 ICTRL VSS 3.7964626688e-16
C12 ICTRL VSS 1.14784566605e-14
C13 ICTRL VSS 1.13911474968e-14
C14 IN1 VSS 4.6547264064e-18
C15 IN1 VSS 4.88407048269e-15
C16 IN1 VSS 9.77673725519e-16
C17 IN1 VSS 2.99233146315e-16
C18 IN1 VSS 2.30160518172e-15
C19 IN1 VSS 1.10023666414e-15
C20 IN1 VSS 4.32224741775e-16
C21 IN1 VSS 1.64967325696e-14
C22 IN1 VSS 1.7589345682e-15
C23 IN1 VSS 1.66692341937e-14
C24 IN2 VSS 1.14422486409e-17
C25 IN2 VSS 7.46553002492e-15
C26 IN2 VSS 3.34172960391e-15
C27 IN2 VSS 5.22578861523e-15
C28 IN2 VSS 8.8763789408e-15
C29 IN2 VSS 2.50483056649e-15
C30 IOUT VSS 8.97878176173e-18
C31 IOUT VSS 3.33857995795e-15
C32 IOUT VSS 2.86198907883e-17
C33 IOUT VSS 8.12919178128e-16
C34 IOUT VSS 7.15682272551e-16
C35 IOUT VSS 1.1222262661e-17
C36 IOUT VSS 2.40502714861e-17
C37 IOUT VSS 9.13911101629e-18
C38 IOUT VSS 1.69972957147e-15
C39 IOUT VSS 7.34856811277e-18
C40 IOUT VSS 4.16871765004e-17
C41 IOUT VSS 7.46361338223e-18
C42 IOUT VSS 6.68327433347e-16
C43 IOUT VSS 9.13911101629e-18
C44 IOUT VSS 4.28916088045e-16
C45 IOUT VSS 2.73720785072e-18
C46 IOUT VSS 2.26062678608e-15
C47 IOUT VSS 9.13911101629e-18
C48 IOUT VSS 5.98545538586e-16
C49 IOUT VSS 7.57864883721e-18
C50 IOUT VSS 7.34856811277e-18
C51 IOUT VSS 7.26867829077e-15
C52 IOUT VSS 7.46361338223e-18
C53 IOUT VSS 7.46361338223e-18
C54 IOUT VSS 5.04381544958e-16
C55 IOUT VSS 3.82083378882e-15
C56 IPB VSS 5.94815299043e-18
C57 IPB VSS 3.96555948178e-15
C58 IPB VSS 9.70849618323e-16
C59 IPB VSS 4.56677535012e-15
C60 IPB VSS 1.59422945113e-15
C61 IPB VSS 4.68783794565e-15
C62 ITAIL VSS 9.80714680626e-18
C63 ITAIL VSS 4.21353581654e-15
C64 ITAIL VSS 1.26092457308e-16
C65 ITAIL VSS 1.81754380084e-15
C66 ITAIL VSS 1.55757885517e-15
C67 ITAIL VSS 6.64220008803e-15
C68 ITAIL VSS 6.41450853909e-15
C69 ITAIL VSS 1.82133296201e-16
C70 KRET VSS 2.76755673641e-15
C71 KRET VSS 2.13039326359e-15
C72 SENSE VSS 1.88106422361e-18
C73 SENSE VSS 3.11700983628e-15
C74 SENSE VSS 1.73532763869e-15
C75 SENSE VSS 1.48107814608e-14
C76 VIN VSS 2.09024142574e-17
C77 VIN VSS 5.30438678449e-15
C78 VIN VSS 1.12030253519e-15
C79 VIN VSS 3.02505435403e-15
C80 VIN VSS 1.73750882435e-17
C81 VIN VSS 1.73750882435e-17
C82 VIN VSS 4.19914528087e-15
C83 VIN VSS 1.71072739245e-17
C84 VIN VSS 2.12756628452e-17
C85 VIN VSS 2.12756628452e-17
C86 VIN VSS 1.76429025626e-17
C87 VIN VSS 1.1597980995e-14
C88 VIN VSS 5.598855676e-17
C89 VIN VSS 1.33218594801e-15
C90 VIN VSS 5.598855676e-17
C91 VIN VSS 1.73750882435e-17
C92 VIN VSS 1.73750882435e-17
C93 VIN VSS 5.03896869885e-15
C94 VIN VSS 3.02505435403e-15
C95 VIN VSS 1.76429025626e-17
C96 VIN VSS 1.71072739245e-17
C97 VIN VSS 9.66351588225e-15
C98 VIN VSS 1.73750882435e-17
C99 VIN VSS 1.73750882435e-17
C100 VIN VSS 1.33218594801e-15
C101 VIN VSS 2.59018732965e-15
C102 VIN VSS 1.11469957773e-15
C103 VIN VSS 1.2616098272e-16
C104 VIN VSS 2.61251458656e-17
C105 VIN VSS 5.598855676e-17
C106 VIN VSS 2.12756628452e-17
C107 VIN VSS 1.15982629048e-14
C108 VIN VSS 1.71072739245e-17
C109 VIN VSS 9.70467471443e-17
C110 VIN VSS 1.73750882435e-17
C111 VIN VSS 1.33218594801e-15
C112 VIN VSS 5.598855676e-17
C113 VIN VSS 7.96663026144e-16
C114 VIN VSS 6.37215542668e-18
C115 VIN VSS 4.36722695704e-15
C116 VIN VSS 2.12756628452e-17
C117 VIN VSS 2.12756628452e-17
C118 VIN VSS 6.15874265314e-15
C119 VIN VSS 1.71072739245e-17
C120 VIN VSS 2.12756628452e-17
C121 VIN VSS 2.12756628452e-17
C122 VIN VSS 5.598855676e-17
C123 VIN VSS 1.76429025626e-17
C124 VIN VSS 4.9111155525e-15
C125 VIN VSS 5.598855676e-17
C126 VIN VSS 2.0949563673e-15
C127 VIN VSS 5.598855676e-17
C128 VIN VSS 2.12756628452e-17
C129 VIN VSS 2.12756628452e-17
C130 VIN VSS 1.71072739245e-17
C131 VIN VSS 2.12756628452e-17
C132 VIN VSS 2.12756628452e-17
C133 VIN VSS 2.12756628452e-17
C134 VIN VSS 1.76429025626e-17
C135 VIN VSS 4.9111155525e-15
C136 VIN VSS 5.598855676e-17
C137 VIN VSS 1.47335228511e-15
C138 VIN VSS 1.73750882435e-17
C139 VIN VSS 1.73750882435e-17
C140 VIN VSS 4.41189556635e-15
C141 VIN VSS 1.71072739245e-17
C142 VIN VSS 2.12756628452e-17
C143 VIN VSS 2.12756628452e-17
C144 VIN VSS 2.12756628452e-17
C145 VIN VSS 1.76429025626e-17
C146 VIN VSS 4.22918981882e-14
C147 VIN VSS 5.598855676e-17
C148 VIN VSS 1.33218594801e-15
C149 VIN VSS 1.73750882435e-17
C150 VIN VSS 1.73750882435e-17
C151 VIN VSS 6.15874265314e-15
C152 VIN VSS 4.9111155525e-15
C153 VIN VSS 1.76429025626e-17
C154 VIN VSS 1.71072739245e-17
C155 VIN VSS 8.46546966934e-15
C156 VIN VSS 6.15874265314e-15
C157 VIN VSS 1.73750882435e-17
C158 VIN VSS 1.73750882435e-17
C159 VIN VSS 1.33218594801e-15
C160 VIN VSS 1.19495225274e-15
C161 VIN VSS 5.598855676e-17
C162 VIN VSS 2.12756628452e-17
C163 VIN VSS 4.22918981882e-14
C164 VIN VSS 1.76429025626e-17
C165 VIN VSS 1.71072739245e-17
C166 VIN VSS 1.71072739245e-17
C167 VIN VSS 2.12756628452e-17
C168 VIN VSS 1.73750882435e-17
C169 VIN VSS 1.73750882435e-17
C170 VIN VSS 1.33218594801e-15
C171 VIN VSS 1.19495225274e-15
C172 VIN VSS 1.19495225274e-15
C173 VIN VSS 1.33218594801e-15
C174 VIN VSS 1.73750882435e-17
C175 VIN VSS 1.73750882435e-17
C176 VIN VSS 6.15874265314e-15
C177 VIN VSS 2.12756628452e-17
C178 VIN VSS 1.71072739245e-17
C179 VIN VSS 2.12756628452e-17
C180 VIN VSS 2.12756628452e-17
C181 VIN VSS 1.76429025626e-17
C182 VIN VSS 4.22918981882e-14
C183 VIN VSS 5.598855676e-17
C184 VIN VSS 1.33218594801e-15
C185 VIN VSS 1.73750882435e-17
C186 VIN VSS 1.73750882435e-17
C187 VIN VSS 2.70873040454e-14
C188 VIN VSS 2.12756628452e-17
C189 VIN VSS 4.22918981882e-14
C190 VIN VSS 1.76429025626e-17
C191 VIN VSS 1.71072739245e-17
C192 VIN VSS 2.96739675024e-14
C193 VIN VSS 1.73750882435e-17
C194 VIN VSS 1.73750882435e-17
C195 VIN VSS 1.33218594801e-15
C196 VIN VSS 2.76263156011e-15
C197 VIN VSS 5.598855676e-17
C198 VIN VSS 2.12756628452e-17
C199 VIN VSS 1.76429025626e-17
C200 VIN VSS 4.22918981882e-14
C201 VIN VSS 1.76429025626e-17
C202 VIN VSS 1.71072739245e-17
C203 VIN VSS 2.12756628452e-17
C204 VIN VSS 1.73750882435e-17
C205 VIN VSS 1.73750882435e-17
C206 VIN VSS 1.33218594801e-15
C207 VIN VSS 1.34873405382e-15
C208 VIN VSS 1.06431524702e-15
C209 VIN VSS 1.33218594801e-15
C210 VIN VSS 9.99208176521e-14
C211 VIN VSS 9.80665558802e-15
C212 VIN VSS 1.04332001396e-14
C213 VIN VSS 2.95848135252e-15
C214 VIN VSS 9.99208176521e-14
C215 VIN VSS 9.80665558802e-15
C216 VIN VSS 9.99208176521e-14
C217 VIN VSS 9.80665558802e-15
C218 VIN VSS 9.99208176521e-14
C219 VIN VSS 9.99208176521e-14
C220 VIN VSS 1.04332001396e-14
C221 VIN VSS 2.95848135252e-15
C222 VSET VSS 1.2679285546e-15
C223 VSET VSS 8.1159714454e-15
C224 ICTRL IOUT 7.17502e-15
C225 ITAIL IN2 1.13766e-16
C226 IPB ITAIL 1.35408e-15
C227 VIN VSET 4.33839e-15
C228 IN1 SENSE 6.93405e-17
C229 VIN IN1 1.25166e-14
C230 IOUT DISABLE 1.26984e-15
C231 IN1 IN2 2.95668e-15
C232 ITAIL VSET 5.60671e-15
C233 VIN SENSE 1.61167e-14
C234 ICTRL SENSE 5.76417e-15
C235 SENSE IN2 6.00612e-15
C236 ITAIL IN1 6.97867e-16
C237 VIN IN2 1.20698e-14
C238 ICTRL VIN 4.25313e-14
C239 VIN IPB 1.22128e-14
C240 DISABLE KRET 5.27759e-16
C241 ICTRL IN2 1.15305e-15
C242 IOUT VIN 1.42834e-14
C243 ITAIL SENSE 5.60611e-15
C244 VSET IN1 5.60438e-15
C245 VIN ITAIL 2.34124e-14
.ends nrz_vi_reference
