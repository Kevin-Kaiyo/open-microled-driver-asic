* NGSPICE file created from nrz_vi_reference.ext - technology: gf180mcuD

.subckt nrz_vi_reference VIN VSS VSET SENSE IOUT IPB IN2 ICTRL DISABLE KRET
X0 VSS IN1 IN2 VSS nfet_06v0 ad=22p pd=0.10088m as=22p ps=0.10088m w=50u l=10u
X1 VSS IN1 IN1 VSS nfet_06v0 ad=22p pd=0.10088m as=22p ps=0.10088m w=50u l=10u
X2 VIN ICTRL IOUT VIN pfet_06v0 ad=44p pd=0.20088m as=44p ps=0.20088m w=100u l=10u
X3 VIN ICTRL ICTRL VIN pfet_06v0 ad=44p pd=0.20088m as=44p ps=0.20088m w=100u l=10u
X4 VSS DISABLE IOUT VSS nfet_06v0 ad=4.4p pd=20.88u as=4.4p ps=20.88u w=10u l=0.7u
X5 ITAIL SENSE IN2 VIN pfet_06v0 ad=44p pd=0.20088m as=44p ps=0.20088m w=100u l=10u
X6 VSS IN2 ICTRL VSS nfet_06v0 ad=8.8p pd=40.88u as=8.8p ps=40.88u w=20u l=1u
X7 VIN IPB IPB VIN pfet_06v0 ad=8.8p pd=40.88u as=8.8p ps=40.88u w=20u l=4u
X8 VIN ICTRL SENSE VIN pfet_06v0 ad=44p pd=0.20088m as=44p ps=0.20088m w=100u l=10u
X9 ITAIL VSET IN1 VIN pfet_06v0 ad=44p pd=0.20088m as=44p ps=0.20088m w=100u l=10u
X10 VIN IPB ITAIL VIN pfet_06v0 ad=8.8p pd=40.88u as=8.8p ps=40.88u w=20u l=4u
X11 VSS DISABLE KRET VSS nfet_06v0 ad=0.44p pd=2.88u as=0.44p ps=2.88u w=1u l=0.7u
C0 VIN ICTRL 42.5313f
C1 ITAIL VIN 23.4124f
C2 VIN IN2 12.0698f
C3 ICTRL IOUT 7.17502f
C4 VIN SENSE 16.1167f
C5 ITAIL IN1 0.69787f
C6 VIN VSET 4.33839f
C7 IN1 IN2 2.95668f
C8 IN2 ICTRL 1.15305f
C9 ITAIL IN2 0.11377f
C10 IN1 SENSE 0.06934f
C11 VIN IPB 12.2128f
C12 SENSE ICTRL 5.76417f
C13 ITAIL SENSE 5.60611f
C14 IN1 VSET 5.60438f
C15 DISABLE KRET 0.52776f
C16 SENSE IN2 6.00612f
C17 ITAIL VSET 5.60671f
C18 VIN IOUT 14.2834f
C19 ITAIL IPB 1.35408f
C20 IN1 VIN 12.5166f
C21 IOUT DISABLE 1.26984f
C22 KRET VSS 4.89795f
C23 IOUT VSS 50.77155f
C24 SENSE VSS 14.93012f
C25 VIN VSS 1.01269p
C26 IN1 VSS 4.69195f
C27 ITAIL VSS 35.48785f
.ends
