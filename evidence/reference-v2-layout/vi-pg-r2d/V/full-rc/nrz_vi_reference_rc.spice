* Audited RC model assembly from build/reference-v2-layout/vi-pg-r2d/V/readback/nrz_vi_reference.ext.
* Original Magic RC preserved in ../unmodified-full-rc/.
* R/MOS unchanged; C counted once with post-simplification allocation weights.
* Coupling remains at original logical nodes; no EM claim.
.subckt nrz_vi_reference VIN VSS VSET SENSE IOUT IPB IN2 ICTRL
X0 VSS.t5 IN1.t3 IN2.t0 VSS.t4 nfet_06v0 ad=22p pd=0.10088m as=22p ps=0.10088m w=50u l=10u
X1 VSS.t3 IN1.t1 IN1.t2 VSS.t2 nfet_06v0 ad=22p pd=0.10088m as=22p ps=0.10088m w=50u l=10u
X2 VIN.t1 ICTRL.t3 IOUT.t0 VIN.t0 pfet_06v0 ad=44p pd=0.20088m as=44p ps=0.20088m w=100u l=10u
X3 VIN.t3 ICTRL.t0 ICTRL.t1 VIN.t2 pfet_06v0 ad=44p pd=0.20088m as=44p ps=0.20088m w=100u l=10u
X4 ITAIL.t0 SENSE.t1 IN2.t1 VIN.t6 pfet_06v0 ad=44p pd=0.20088m as=44p ps=0.20088m w=100u l=10u
X5 VSS.t1 IN2.t2 ICTRL.t2 VSS.t0 nfet_06v0 ad=8.8p pd=40.88u as=8.8p ps=40.88u w=20u l=1u
X6 VIN.t11 IPB.t0 IPB.t1 VIN.t10 pfet_06v0 ad=8.8p pd=40.88u as=8.8p ps=40.88u w=20u l=4u
X7 VIN.t5 ICTRL.t4 SENSE.t0 VIN.t4 pfet_06v0 ad=44p pd=0.20088m as=44p ps=0.20088m w=100u l=10u
X8 ITAIL.t1 VSET.t0 IN1.t0 VIN.t7 pfet_06v0 ad=44p pd=0.20088m as=44p ps=0.20088m w=100u l=10u
X9 VIN.t9 IPB.t2 ITAIL.t2 VIN.t8 pfet_06v0 ad=8.8p pd=40.88u as=8.8p ps=40.88u w=20u l=4u
R0 IOUT.n8 IOUT.n7 21.199
R1 IOUT.n3 IOUT.t0 7.79795
R2 IOUT.n4 IOUT.n3 4.57095
R3 IOUT.n6 IOUT.n0 4.5005
R4 IOUT.n7 IOUT.n6 4.5005
R5 IOUT.n5 IOUT.n2 4.5005
R6 IOUT.n9 IOUT.n0 3.96604
R7 IOUT.n4 IOUT.n0 2.21603
R8 IOUT.n9 IOUT.n8 1.50173
R9 IOUT.n6 IOUT.n5 0.142605
R10 IOUT.n5 IOUT.n4 0.0709482
R11 IOUT.n7 IOUT.n2 0.0545
R12 IOUT.n3 IOUT.n2 0.0545
R13 IOUT.n8 IOUT.n1 0.0388491
R14 IOUT IOUT.n9 0.006125
R15 ICTRL.n0 ICTRL.t3 104.13
R16 ICTRL.n0 ICTRL.t4 99.1807
R17 ICTRL.n1 ICTRL.t0 99.1807
R18 ICTRL.n2 ICTRL.t1 41.0168
R19 ICTRL.n3 ICTRL.t2 31.7324
R20 ICTRL.n1 ICTRL.n0 4.9505
R21 ICTRL.n3 ICTRL.n2 3.038
R22 ICTRL.n2 ICTRL.n1 1.184
R23 ICTRL ICTRL.n3 0.0905
R24 IN2.n0 IN2.t2 130.244
R25 IN2.n1 IN2.t1 41.4905
R26 IN2.n0 IN2.t0 35.619
R27 IN2.n1 IN2.n0 9.9005
R28 IN2 IN2.n1 0.0905
R29 SENSE.n0 SENSE.t1 101.076
R30 SENSE.n0 SENSE.t0 65.578
R31 SENSE SENSE.n0 0.0905
R32 VSET VSET.t0 101.639
R33 IPB.n0 IPB.t2 68.1472
R34 IPB.n0 IPB.t0 64.0972
R35 IPB.n1 IPB.t1 32.6627
R36 IPB.n1 IPB.n0 0.509
R37 IPB IPB.n1 0.0905
R38 VIN.n107 VIN.t8 102.373
R39 VIN.n125 VIN.t10 102.373
R40 VIN.n74 VIN.t2 64.616
R41 VIN.n41 VIN.t0 64.616
R42 VIN.n57 VIN.t4 64.616
R43 VIN.n90 VIN.t7 64.616
R44 VIN.n80 VIN.t6 64.616
R45 VIN.n33 VIN.n23 21.1752
R46 VIN.n87 VIN.n12 18.9005
R47 VIN.n120 VIN.n119 18.3042
R48 VIN.n109 VIN.n1 18.3042
R49 VIN.n54 VIN.n53 18.3042
R50 VIN.n130 VIN.n129 18.3042
R51 VIN.n97 VIN.n96 18.3042
R52 VIN.n43 VIN.n23 18.3042
R53 VIN.n99 VIN.n98 18.3042
R54 VIN.n76 VIN.n12 18.3042
R55 VIN.n66 VIN.n65 18.3042
R56 VIN.n64 VIN.n63 18.3042
R57 VIN.n87 VIN.n86 18.3042
R58 VIN.n21 VIN.t3 9.59795
R59 VIN.n47 VIN.t5 9.59795
R60 VIN.n31 VIN.t1 9.59795
R61 VIN.n113 VIN.t11 6.17014
R62 VIN.n10 VIN.t9 6.17014
R63 VIN.n97 VIN.n87 4.9505
R64 VIN.n115 VIN.n114 4.57095
R65 VIN.n40 VIN.n37 4.57095
R66 VIN.n126 VIN.n125 4.57095
R67 VIN.n9 VIN.n6 4.57095
R68 VIN.n49 VIN.n48 4.57095
R69 VIN.n73 VIN.n70 4.57095
R70 VIN.n92 VIN.n91 4.57095
R71 VIN.n20 VIN.n17 4.57095
R72 VIN.n82 VIN.n81 4.57095
R73 VIN.n59 VIN.n58 4.57095
R74 VIN.n30 VIN.n27 4.57095
R75 VIN.n106 VIN.n103 4.57095
R76 VIN.n107 VIN.n106 4.5005
R77 VIN.n108 VIN.n105 4.5005
R78 VIN.n45 VIN.n44 4.5005
R79 VIN.n39 VIN.n38 4.5005
R80 VIN.n72 VIN.n71 4.5005
R81 VIN.n96 VIN.n95 4.5005
R82 VIN.n77 VIN.n76 4.5005
R83 VIN.n75 VIN.n72 4.5005
R84 VIN.n74 VIN.n73 4.5005
R85 VIN.n128 VIN.n127 4.5005
R86 VIN.n93 VIN.n89 4.5005
R87 VIN.n81 VIN.n80 4.5005
R88 VIN.n85 VIN.n84 4.5005
R89 VIN.n15 VIN.n14 4.5005
R90 VIN.n14 VIN.n13 4.5005
R91 VIN.n86 VIN.n85 4.5005
R92 VIN.n129 VIN.n128 4.5005
R93 VIN.n124 VIN.n123 4.5005
R94 VIN.n132 VIN.n121 4.5005
R95 VIN.n95 VIN.n94 4.5005
R96 VIN.n94 VIN.n5 4.5005
R97 VIN.n117 VIN.n116 4.5005
R98 VIN.n112 VIN.n111 4.5005
R99 VIN.n102 VIN.n101 4.5005
R100 VIN.n84 VIN.n83 4.5005
R101 VIN.n79 VIN.n78 4.5005
R102 VIN.n69 VIN.n68 4.5005
R103 VIN.n61 VIN.n16 4.5005
R104 VIN.n51 VIN.n50 4.5005
R105 VIN.n46 VIN.n45 4.5005
R106 VIN.n36 VIN.n35 4.5005
R107 VIN.n114 VIN.n113 4.5005
R108 VIN.n3 VIN.n2 4.5005
R109 VIN.n119 VIN.n118 4.5005
R110 VIN.n4 VIN.n3 4.5005
R111 VIN.n118 VIN.n117 4.5005
R112 VIN.n35 VIN.n34 4.5005
R113 VIN.n29 VIN.n28 4.5005
R114 VIN.n34 VIN.n33 4.5005
R115 VIN.n32 VIN.n29 4.5005
R116 VIN.n31 VIN.n30 4.5005
R117 VIN.n91 VIN.n90 4.5005
R118 VIN.n41 VIN.n40 4.5005
R119 VIN.n105 VIN.n104 4.5005
R120 VIN.n52 VIN.n51 4.5005
R121 VIN.n26 VIN.n25 4.5005
R122 VIN.n111 VIN.n110 4.5005
R123 VIN.n53 VIN.n52 4.5005
R124 VIN.n25 VIN.n24 4.5005
R125 VIN.n48 VIN.n47 4.5005
R126 VIN.n62 VIN.n61 4.5005
R127 VIN.n60 VIN.n56 4.5005
R128 VIN.n10 VIN.n9 4.5005
R129 VIN.n63 VIN.n62 4.5005
R130 VIN.n56 VIN.n55 4.5005
R131 VIN.n58 VIN.n57 4.5005
R132 VIN.n11 VIN.n8 4.5005
R133 VIN.n100 VIN.n99 4.5005
R134 VIN.n68 VIN.n67 4.5005
R135 VIN.n19 VIN.n18 4.5005
R136 VIN.n8 VIN.n7 4.5005
R137 VIN.n67 VIN.n66 4.5005
R138 VIN.n22 VIN.n19 4.5005
R139 VIN.n21 VIN.n20 4.5005
R140 VIN.n89 VIN.n88 4.5005
R141 VIN.n101 VIN.n100 4.5005
R142 VIN.n42 VIN.n39 4.5005
R143 VIN.n110 VIN.n109 4.5005
R144 VIN.n44 VIN.n43 4.5005
R145 VIN.n78 VIN.n77 4.5005
R146 VIN.n132 VIN.n0 3.28376
R147 VIN.n65 VIN.n12 2.8715
R148 VIN.n64 VIN.n54 2.8715
R149 VIN.n120 VIN.n1 2.5295
R150 VIN.n132 VIN.n131 2.27432
R151 VIN.n83 VIN.n82 2.21603
R152 VIN.n69 VIN.n17 2.21603
R153 VIN.n102 VIN.n6 2.21603
R154 VIN.n36 VIN.n27 2.21603
R155 VIN.n46 VIN.n37 2.21603
R156 VIN.n50 VIN.n49 2.21603
R157 VIN.n59 VIN.n16 2.21603
R158 VIN.n112 VIN.n103 2.21603
R159 VIN.n92 VIN.n5 2.21603
R160 VIN.n116 VIN.n115 2.21603
R161 VIN.n127 VIN.n126 2.21603
R162 VIN.n79 VIN.n70 2.21603
R163 VIN.n54 VIN.n23 2.0795
R164 VIN.n65 VIN.n64 2.0795
R165 VIN.n98 VIN.n97 1.8545
R166 VIN.n98 VIN.n1 1.5215
R167 VIN.n121 VIN.n120 1.454
R168 VIN.n116 VIN.n0 0.847054
R169 VIN.n83 VIN.n79 0.5605
R170 VIN.n83 VIN.n5 0.147167
R171 VIN.n128 VIN.n124 0.142605
R172 VIN.n35 VIN.n28 0.142605
R173 VIN.n34 VIN.n29 0.142605
R174 VIN.n30 VIN.n29 0.142605
R175 VIN.n45 VIN.n38 0.142605
R176 VIN.n44 VIN.n39 0.142605
R177 VIN.n40 VIN.n39 0.142605
R178 VIN.n51 VIN.n26 0.142605
R179 VIN.n52 VIN.n25 0.142605
R180 VIN.n48 VIN.n25 0.142605
R181 VIN.n62 VIN.n56 0.142605
R182 VIN.n58 VIN.n56 0.142605
R183 VIN.n68 VIN.n18 0.142605
R184 VIN.n67 VIN.n19 0.142605
R185 VIN.n20 VIN.n19 0.142605
R186 VIN.n78 VIN.n71 0.142605
R187 VIN.n77 VIN.n72 0.142605
R188 VIN.n73 VIN.n72 0.142605
R189 VIN.n84 VIN.n15 0.142605
R190 VIN.n85 VIN.n14 0.142605
R191 VIN.n81 VIN.n14 0.142605
R192 VIN.n101 VIN.n7 0.142605
R193 VIN.n100 VIN.n8 0.142605
R194 VIN.n9 VIN.n8 0.142605
R195 VIN.n111 VIN.n104 0.142605
R196 VIN.n110 VIN.n105 0.142605
R197 VIN.n106 VIN.n105 0.142605
R198 VIN.n117 VIN.n4 0.142605
R199 VIN.n118 VIN.n3 0.142605
R200 VIN.n114 VIN.n3 0.142605
R201 VIN.n94 VIN.n93 0.142605
R202 VIN.n95 VIN.n89 0.142605
R203 VIN.n91 VIN.n89 0.142605
R204 VIN.n61 VIN.n60 0.142605
R205 VIN.n79 VIN.n69 0.0855667
R206 VIN.n50 VIN.n16 0.0855667
R207 VIN.n46 VIN.n36 0.0855667
R208 VIN.n131 VIN.n130 0.079578
R209 VIN.n116 VIN.n112 0.0754333
R210 VIN.n115 VIN.n4 0.0709482
R211 VIN.n18 VIN.n17 0.0709482
R212 VIN.n28 VIN.n27 0.0709482
R213 VIN.n7 VIN.n6 0.0709482
R214 VIN.n38 VIN.n37 0.0709482
R215 VIN.n71 VIN.n70 0.0709482
R216 VIN.n93 VIN.n92 0.0709482
R217 VIN.n104 VIN.n103 0.0709482
R218 VIN.n60 VIN.n59 0.0709482
R219 VIN.n82 VIN.n15 0.0709482
R220 VIN.n49 VIN.n26 0.0709482
R221 VIN.n126 VIN.n124 0.0709482
R222 VIN.n130 VIN.n121 0.068
R223 VIN.n50 VIN.n46 0.0621
R224 VIN.n69 VIN.n16 0.0621
R225 VIN.n102 VIN.n5 0.0554333
R226 VIN.n99 VIN.n11 0.0545
R227 VIN.n11 VIN.n10 0.0545
R228 VIN.n47 VIN.n24 0.0545
R229 VIN.n53 VIN.n24 0.0545
R230 VIN.n42 VIN.n41 0.0545
R231 VIN.n43 VIN.n42 0.0545
R232 VIN.n32 VIN.n31 0.0545
R233 VIN.n33 VIN.n32 0.0545
R234 VIN.n109 VIN.n108 0.0545
R235 VIN.n108 VIN.n107 0.0545
R236 VIN.n96 VIN.n88 0.0545
R237 VIN.n90 VIN.n88 0.0545
R238 VIN.n119 VIN.n2 0.0545
R239 VIN.n113 VIN.n2 0.0545
R240 VIN.n22 VIN.n21 0.0545
R241 VIN.n66 VIN.n22 0.0545
R242 VIN.n57 VIN.n55 0.0545
R243 VIN.n125 VIN.n123 0.0545
R244 VIN.n75 VIN.n74 0.0545
R245 VIN.n63 VIN.n55 0.0545
R246 VIN.n129 VIN.n123 0.0545
R247 VIN.n76 VIN.n75 0.0545
R248 VIN.n86 VIN.n13 0.0545
R249 VIN.n80 VIN.n13 0.0545
R250 VIN.n112 VIN.n102 0.0455667
R251 VIN.n131 VIN.n122 0.0123666
R252 VIN.n127 VIN.n0 0.00877641
R253 VIN VIN.n132 0.006125
R254 VSS.n69 VSS.n6 621.611
R255 VSS.n29 VSS.n7 621.444
R256 VSS.n6 VSS.n5 621.444
R257 VSS.n70 VSS.n5 621.444
R258 VSS.n66 VSS.n7 621.444
R259 VSS.n29 VSS.n8 621.444
R260 VSS.n66 VSS.n8 621.444
R261 VSS.n31 VSS.n30 458.818
R262 VSS.n68 VSS.n67 316.796
R263 VSS.t2 VSS.n68 188.69
R264 VSS.n67 VSS.t4 188.69
R265 VSS.n30 VSS.t4 188.69
R266 VSS.n70 VSS.n69 144.732
R267 VSS.n31 VSS.t0 33.7241
R268 VSS.n22 VSS.n12 21.1574
R269 VSS.n46 VSS.n45 20.1989
R270 VSS.n33 VSS.n12 20.1989
R271 VSS.n57 VSS.n56 20.1989
R272 VSS.n76 VSS.n75 20.1989
R273 VSS.n59 VSS.n58 20.1989
R274 VSS.n39 VSS.t5 6.49753
R275 VSS.n50 VSS.t3 6.49753
R276 VSS.n66 VSS.n65 6.42734
R277 VSS.n71 VSS.n70 6.42734
R278 VSS.n35 VSS.n31 5.33241
R279 VSS.n20 VSS.t1 5.28723
R280 VSS.n41 VSS.n40 4.57095
R281 VSS.n52 VSS.n51 4.57095
R282 VSS.n72 VSS.n71 4.57095
R283 VSS.n19 VSS.n16 4.57095
R284 VSS.n32 VSS.n26 4.57095
R285 VSS.n64 VSS.n63 4.57095
R286 VSS.n74 VSS.n73 4.5005
R287 VSS.n75 VSS.n74 4.5005
R288 VSS.n4 VSS.n3 4.5005
R289 VSS.n33 VSS.n32 4.5005
R290 VSS.n34 VSS.n28 4.5005
R291 VSS.n36 VSS.n35 4.5005
R292 VSS.n37 VSS.n36 4.5005
R293 VSS.n28 VSS.n27 4.5005
R294 VSS.n38 VSS.n37 4.5005
R295 VSS.n54 VSS.n53 4.5005
R296 VSS.n61 VSS.n11 4.5005
R297 VSS.n43 VSS.n42 4.5005
R298 VSS.n25 VSS.n24 4.5005
R299 VSS.n24 VSS.n23 4.5005
R300 VSS.n18 VSS.n17 4.5005
R301 VSS.n23 VSS.n22 4.5005
R302 VSS.n21 VSS.n18 4.5005
R303 VSS.n20 VSS.n19 4.5005
R304 VSS.n44 VSS.n43 4.5005
R305 VSS.n15 VSS.n14 4.5005
R306 VSS.n45 VSS.n44 4.5005
R307 VSS.n14 VSS.n13 4.5005
R308 VSS.n40 VSS.n39 4.5005
R309 VSS.n61 VSS.n60 4.5005
R310 VSS.n62 VSS.n10 4.5005
R311 VSS.n60 VSS.n59 4.5005
R312 VSS.n10 VSS.n9 4.5005
R313 VSS.n65 VSS.n64 4.5005
R314 VSS.n55 VSS.n54 4.5005
R315 VSS.n49 VSS.n48 4.5005
R316 VSS.n56 VSS.n55 4.5005
R317 VSS.n48 VSS.n47 4.5005
R318 VSS.n51 VSS.n50 4.5005
R319 VSS.n78 VSS.n1 4.5005
R320 VSS.n78 VSS.n0 3.73376
R321 VSS.n46 VSS.n12 2.9795
R322 VSS.n58 VSS.n46 2.8715
R323 VSS.n57 VSS.n1 2.804
R324 VSS.n78 VSS.n77 2.27432
R325 VSS.n73 VSS.n72 2.21603
R326 VSS.n63 VSS.n11 2.21603
R327 VSS.n38 VSS.n26 2.21603
R328 VSS.n42 VSS.n41 2.21603
R329 VSS.n53 VSS.n52 2.21603
R330 VSS.n25 VSS.n16 2.21603
R331 VSS.n58 VSS.n57 2.0795
R332 VSS.n53 VSS.n0 0.887054
R333 VSS.n7 VSS.t4 0.217167
R334 VSS.t2 VSS.n5 0.217167
R335 VSS.n8 VSS.t4 0.217167
R336 VSS.n64 VSS.n10 0.142605
R337 VSS.n24 VSS.n17 0.142605
R338 VSS.n23 VSS.n18 0.142605
R339 VSS.n19 VSS.n18 0.142605
R340 VSS.n60 VSS.n10 0.142605
R341 VSS.n37 VSS.n27 0.142605
R342 VSS.n54 VSS.n49 0.142605
R343 VSS.n43 VSS.n15 0.142605
R344 VSS.n36 VSS.n28 0.142605
R345 VSS.n32 VSS.n28 0.142605
R346 VSS.n51 VSS.n48 0.142605
R347 VSS.n44 VSS.n14 0.142605
R348 VSS.n40 VSS.n14 0.142605
R349 VSS.n62 VSS.n61 0.142605
R350 VSS.n55 VSS.n48 0.142605
R351 VSS.n74 VSS.n4 0.142605
R352 VSS.n42 VSS.n38 0.0887667
R353 VSS.n42 VSS.n11 0.0855667
R354 VSS.n77 VSS.n76 0.079578
R355 VSS.n17 VSS.n16 0.0709482
R356 VSS.n72 VSS.n4 0.0709482
R357 VSS.n27 VSS.n26 0.0709482
R358 VSS.n41 VSS.n15 0.0709482
R359 VSS.n52 VSS.n49 0.0709482
R360 VSS.n63 VSS.n62 0.0709482
R361 VSS.n76 VSS.n1 0.068
R362 VSS.n53 VSS.n11 0.0621
R363 VSS.n56 VSS.n47 0.0545
R364 VSS.n34 VSS.n33 0.0545
R365 VSS.n22 VSS.n21 0.0545
R366 VSS.n45 VSS.n13 0.0545
R367 VSS.n39 VSS.n13 0.0545
R368 VSS.n59 VSS.n9 0.0545
R369 VSS.n35 VSS.n34 0.0545
R370 VSS.n65 VSS.n9 0.0545
R371 VSS.n71 VSS.n3 0.0545
R372 VSS.n75 VSS.n3 0.0545
R373 VSS.n50 VSS.n47 0.0545
R374 VSS.n21 VSS.n20 0.0545
R375 VSS.n69 VSS.t2 0.0514603
R376 VSS.n67 VSS.n66 0.0477727
R377 VSS.n68 VSS.n6 0.0477727
R378 VSS.n30 VSS.n29 0.0477727
R379 VSS.n38 VSS.n25 0.0289
R380 VSS.n77 VSS.n2 0.0123666
R381 VSS.n73 VSS.n0 0.00877641
R382 VSS VSS.n78 0.006125
R383 IN1.n0 IN1.t3 73.0912
R384 IN1.n0 IN1.t1 68.1412
R385 IN1.n4 IN1.n3 40.0512
R386 IN1.n1 IN1.t2 34.198
R387 IN1.n4 IN1.n1 9.9005
R388 IN1.n1 IN1.n0 1.184
R389 IN1 IN1.n4 0.068
R390 IN1.n3 IN1.t0 0.0187
R391 IN1.n3 IN1.n2 0.0131
R392 ITAIL.n0 ITAIL.t0 45.4931
R393 ITAIL.n0 ITAIL.t1 40.5431
R394 ITAIL.n3 ITAIL.n2 31.1506
R395 ITAIL.n3 ITAIL.n0 5.7425
R396 ITAIL.n2 ITAIL.t2 0.0915
R397 ITAIL ITAIL.n3 0.068
R398 ITAIL.n2 ITAIL.n1 0.0635
C0 ICTRL VSS 1.3979960691034887e-18
C1 ICTRL.n0 VSS 3.5044982730760877e-15
C2 ICTRL.n1 VSS 1.7797784455037758e-15
C3 ICTRL.n2 VSS 3.441235461293145e-16
C4 ICTRL.n3 VSS 2.4563514440595566e-16
C5 ICTRL.t0 VSS 1.0973217037217597e-14
C6 ICTRL.t1 VSS 1.0800727812721977e-15
C7 ICTRL.t2 VSS 3.6571738665363536e-16
C8 ICTRL.t3 VSS 1.1057342352454737e-14
C9 ICTRL.t4 VSS 1.0973217037217597e-14
C10 IN1 VSS 4.6709536826342538e-18
C11 IN1.n0 VSS 4.9305943990258502e-15
C12 IN1.n1 VSS 1.0064148251143997e-15
C13 IN1.n2 VSS 3.0027559388363065e-16
C14 IN1.n3 VSS 2.3349855627619871e-15
C15 IN1.n4 VSS 1.1294207403516075e-15
C16 IN1.t0 VSS 4.3373141338746644e-16
C17 IN1.t1 VSS 1.6590865735940768e-14
C18 IN1.t2 VSS 1.7904503652506074e-15
C19 IN1.t3 VSS 1.6762690410601055e-14
C20 IN2 VSS 1.1170650006825024e-17
C21 IN2.n0 VSS 7.2883232637818704e-15
C22 IN2.n1 VSS 3.2624131022178252e-15
C23 IN2.t0 VSS 5.1017420749767739e-15
C24 IN2.t1 VSS 8.6656851002952627e-15
C25 IN2.t2 VSS 2.4453658087214459e-15
C26 IOUT VSS 7.1288309268963343e-18
C27 IOUT.n0 VSS 3.3597675935942919e-15
C28 IOUT.n1 VSS 1.0410837193828978e-17
C29 IOUT.n2 VSS 1.9095147981188725e-17
C30 IOUT.n3 VSS 1.3495248221003721e-15
C31 IOUT.n4 VSS 5.8345314410359908e-18
C32 IOUT.n5 VSS 7.2561531929249506e-18
C33 IOUT.n6 VSS 5.9258812403394504e-18
C34 IOUT.n7 VSS 5.3148559604727112e-16
C35 IOUT.n8 VSS 3.4474948135021903e-16
C36 IOUT.n9 VSS 1.8012123405531062e-15
C37 IOUT.t0 VSS 3.0336087843785253e-15
C38 IPB VSS 5.9297749089863399e-18
C39 IPB.n0 VSS 3.9533029121842809e-15
C40 IPB.n1 VSS 9.6785058084970322e-16
C41 IPB.t0 VSS 4.5526622069985686e-15
C42 IPB.t1 VSS 1.5893030509757652e-15
C43 IPB.t2 VSS 4.6733514740826982e-15
C44 ITAIL VSS 9.9353889077863598e-18
C45 ITAIL.n0 VSS 4.3753319290008766e-15
C46 ITAIL.n1 VSS 1.277408812755814e-16
C47 ITAIL.n2 VSS 1.8952169145358739e-15
C48 ITAIL.n3 VSS 1.6319018828794938e-15
C49 ITAIL.t0 VSS 6.7841059499163504e-15
C50 ITAIL.t1 VSS 6.5523527714271712e-15
C51 ITAIL.t2 VSS 1.8451428205686827e-16
C52 SENSE VSS 1.8541783619998724e-18
C53 SENSE.n0 VSS 3.0724483379870454e-15
C54 SENSE.t0 VSS 1.7105181864367697e-15
C55 SENSE.t1 VSS 1.4599079297214189e-14
C56 VIN VSS 2.0872637189255071e-17
C57 VIN.n0 VSS 5.2968334300195392e-15
C58 VIN.n1 VSS 1.1187036709428631e-15
C59 VIN.n10 VSS 3.0207433496598077e-15
C60 VIN.n100 VSS 1.73503831814601e-17
C61 VIN.n101 VSS 1.73503831814601e-17
C62 VIN.n102 VSS 4.193158192939986e-15
C63 VIN.n103 VSS 1.7082953045156543e-17
C64 VIN.n104 VSS 2.1245322648870947e-17
C65 VIN.n105 VSS 2.1245322648870947e-17
C66 VIN.n106 VSS 1.7617813317763659e-17
C67 VIN.n107 VSS 1.1581462740504068e-14
C68 VIN.n108 VSS 5.5908799358478627e-17
C69 VIN.n109 VSS 1.330283756681368e-15
C70 VIN.n11 VSS 5.5908799358478627e-17
C71 VIN.n110 VSS 1.73503831814601e-17
C72 VIN.n111 VSS 1.73503831814601e-17
C73 VIN.n112 VSS 5.0317884243712549e-15
C74 VIN.n113 VSS 3.0207433496598077e-15
C75 VIN.n114 VSS 1.7617813317763659e-17
C76 VIN.n115 VSS 1.7082953045156543e-17
C77 VIN.n116 VSS 9.6497179832426969e-15
C78 VIN.n117 VSS 1.73503831814601e-17
C79 VIN.n118 VSS 1.73503831814601e-17
C80 VIN.n119 VSS 1.330283756681368e-15
C81 VIN.n12 VSS 2.5864947831600564e-15
C82 VIN.n120 VSS 1.1131102229459851e-15
C83 VIN.n121 VSS 1.2598133477043505e-16
C84 VIN.n122 VSS 2.608791181527485e-17
C85 VIN.n123 VSS 5.5908799358478627e-17
C86 VIN.n124 VSS 2.1245322648870947e-17
C87 VIN.n125 VSS 1.1581744171849822e-14
C88 VIN.n126 VSS 1.7082953045156543e-17
C89 VIN.n127 VSS 9.6908773175593463e-17
C90 VIN.n128 VSS 1.73503831814601e-17
C91 VIN.n129 VSS 1.330283756681368e-15
C92 VIN.n13 VSS 5.5908799358478627e-17
C93 VIN.n130 VSS 7.955219850452675e-16
C94 VIN.n131 VSS 6.3630712623300526e-18
C95 VIN.n132 VSS 4.3610038475481854e-15
C96 VIN.n14 VSS 2.1245322648870947e-17
C97 VIN.n15 VSS 2.1245322648870947e-17
C98 VIN.n16 VSS 6.149964411540827e-15
C99 VIN.n17 VSS 1.7082953045156543e-17
C100 VIN.n18 VSS 2.1245322648870947e-17
C101 VIN.n19 VSS 2.1245322648870947e-17
C102 VIN.n2 VSS 5.5908799358478627e-17
C103 VIN.n20 VSS 1.7617813317763659e-17
C104 VIN.n21 VSS 4.9041170943695615e-15
C105 VIN.n22 VSS 5.5908799358478627e-17
C106 VIN.n23 VSS 2.0919706581832575e-15
C107 VIN.n24 VSS 5.5908799358478627e-17
C108 VIN.n25 VSS 2.1245322648870947e-17
C109 VIN.n26 VSS 2.1245322648870947e-17
C110 VIN.n27 VSS 1.7082953045156543e-17
C111 VIN.n28 VSS 2.1245322648870947e-17
C112 VIN.n29 VSS 2.1245322648870947e-17
C113 VIN.n3 VSS 2.1245322648870947e-17
C114 VIN.n30 VSS 1.7617813317763659e-17
C115 VIN.n31 VSS 4.9041170943695615e-15
C116 VIN.n32 VSS 5.5908799358478627e-17
C117 VIN.n33 VSS 1.4712527177699781e-15
C118 VIN.n34 VSS 1.73503831814601e-17
C119 VIN.n35 VSS 1.73503831814601e-17
C120 VIN.n36 VSS 4.4056107158503314e-15
C121 VIN.n37 VSS 1.7082953045156543e-17
C122 VIN.n38 VSS 2.1245322648870947e-17
C123 VIN.n39 VSS 2.1245322648870947e-17
C124 VIN.n4 VSS 2.1245322648870947e-17
C125 VIN.n40 VSS 1.7617813317763659e-17
C126 VIN.n41 VSS 4.2231658101810986e-14
C127 VIN.n42 VSS 5.5908799358478627e-17
C128 VIN.n43 VSS 1.330283756681368e-15
C129 VIN.n44 VSS 1.73503831814601e-17
C130 VIN.n45 VSS 1.73503831814601e-17
C131 VIN.n46 VSS 6.149964411540827e-15
C132 VIN.n47 VSS 4.9041170943695615e-15
C133 VIN.n48 VSS 1.7617813317763659e-17
C134 VIN.n49 VSS 1.7082953045156543e-17
C135 VIN.n5 VSS 8.4534236902752195e-15
C136 VIN.n50 VSS 6.149964411540827e-15
C137 VIN.n51 VSS 1.73503831814601e-17
C138 VIN.n52 VSS 1.73503831814601e-17
C139 VIN.n53 VSS 1.330283756681368e-15
C140 VIN.n54 VSS 1.1932477986496822e-15
C141 VIN.n55 VSS 5.5908799358478627e-17
C142 VIN.n56 VSS 2.1245322648870947e-17
C143 VIN.n57 VSS 4.2231658101810986e-14
C144 VIN.n58 VSS 1.7617813317763659e-17
C145 VIN.n59 VSS 1.7082953045156543e-17
C146 VIN.n6 VSS 1.7082953045156543e-17
C147 VIN.n60 VSS 2.1245322648870947e-17
C148 VIN.n61 VSS 1.73503831814601e-17
C149 VIN.n62 VSS 1.73503831814601e-17
C150 VIN.n63 VSS 1.330283756681368e-15
C151 VIN.n64 VSS 1.1932477986496822e-15
C152 VIN.n65 VSS 1.1932477986496822e-15
C153 VIN.n66 VSS 1.330283756681368e-15
C154 VIN.n67 VSS 1.73503831814601e-17
C155 VIN.n68 VSS 1.73503831814601e-17
C156 VIN.n69 VSS 6.149964411540827e-15
C157 VIN.n7 VSS 2.1245322648870947e-17
C158 VIN.n70 VSS 1.7082953045156543e-17
C159 VIN.n71 VSS 2.1245322648870947e-17
C160 VIN.n72 VSS 2.1245322648870947e-17
C161 VIN.n73 VSS 1.7617813317763659e-17
C162 VIN.n74 VSS 4.2231658101810986e-14
C163 VIN.n75 VSS 5.5908799358478627e-17
C164 VIN.n76 VSS 1.330283756681368e-15
C165 VIN.n77 VSS 1.73503831814601e-17
C166 VIN.n78 VSS 1.73503831814601e-17
C167 VIN.n79 VSS 2.7048648071845513e-14
C168 VIN.n8 VSS 2.1245322648870947e-17
C169 VIN.n80 VSS 4.2231658101810986e-14
C170 VIN.n81 VSS 1.7617813317763659e-17
C171 VIN.n82 VSS 1.7082953045156543e-17
C172 VIN.n83 VSS 2.9631624963183634e-14
C173 VIN.n84 VSS 1.73503831814601e-17
C174 VIN.n85 VSS 1.73503831814601e-17
C175 VIN.n86 VSS 1.330283756681368e-15
C176 VIN.n87 VSS 2.7586955878438124e-15
C177 VIN.n88 VSS 5.5908799358478627e-17
C178 VIN.n89 VSS 2.1245322648870947e-17
C179 VIN.n9 VSS 1.7617813317763659e-17
C180 VIN.n90 VSS 4.2231658101810986e-14
C181 VIN.n91 VSS 1.7617813317763659e-17
C182 VIN.n92 VSS 1.7082953045156543e-17
C183 VIN.n93 VSS 2.1245322648870947e-17
C184 VIN.n94 VSS 1.73503831814601e-17
C185 VIN.n95 VSS 1.73503831814601e-17
C186 VIN.n96 VSS 1.330283756681368e-15
C187 VIN.n97 VSS 1.3468108124608221e-15
C188 VIN.n98 VSS 1.0627973341086597e-15
C189 VIN.n99 VSS 1.330283756681368e-15
C190 VIN.t0 VSS 9.9777965745564267e-14
C191 VIN.t1 VSS 9.7926851068861667e-15
C192 VIN.t10 VSS 1.0418377346335664e-14
C193 VIN.t11 VSS 2.954262230008866e-15
C194 VIN.t2 VSS 9.9777965745564267e-14
C195 VIN.t3 VSS 9.7926851068861667e-15
C196 VIN.t4 VSS 9.9777965745564267e-14
C197 VIN.t5 VSS 9.7926851068861667e-15
C198 VIN.t6 VSS 9.9777965745564267e-14
C199 VIN.t7 VSS 9.9777965745564267e-14
C200 VIN.t8 VSS 1.0418377346335664e-14
C201 VIN.t9 VSS 2.954262230008866e-15
C202 VSET VSS 1.2672283577813648e-15
C203 VSET.t0 VSS 8.1114816422186361e-15
C204 IN1 IN2 3.1853200000000003e-15
C205 ITAIL VSET 5.6111499999999997e-15
C206 VIN SENSE 1.6319400000000001e-14
C207 SENSE IN2 6.0049600000000005e-15
C208 ITAIL IN1 6.9786699999999999e-16
C209 VIN IN2 1.2069800000000001e-14
C210 VIN IPB 1.2210600000000002e-14
C211 ICTRL IOUT 6.6740200000000011e-15
C212 ITAIL SENSE 5.6093800000000004e-15
C213 VSET IN1 5.6088200000000003e-15
C214 VIN ITAIL 2.3478000000000002e-14
C215 ICTRL SENSE 5.7641700000000007e-15
C216 ICTRL VIN 4.2539900000000006e-14
C217 ITAIL IN2 1.61524e-16
C218 IPB ITAIL 1.3862000000000001e-15
C219 VIN VSET 4.3374900000000002e-15
C220 ICTRL IN2 1.1530500000000001e-15
C221 IOUT VIN 1.4002800000000001e-14
C222 IN1 SENSE 6.9340500000000005e-17
C223 VIN IN1 1.2560900000000001e-14
.ends nrz_vi_reference
