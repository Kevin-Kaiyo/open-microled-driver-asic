* NGSPICE file created from nrz_vi_reference.ext - technology: gf180mcuD

X0 VSS IN1 IN2 VSS nfet_06v0 ad=22p pd=0.10088m as=22p ps=0.10088m w=50u l=10u
X1 VSS IN1 IN1 VSS nfet_06v0 ad=22p pd=0.10088m as=22p ps=0.10088m w=50u l=10u
X2 VIN ICTRL IOUT VIN pfet_06v0 ad=44p pd=0.20088m as=44p ps=0.20088m w=100u l=10u
X3 VIN ICTRL ICTRL VIN pfet_06v0 ad=44p pd=0.20088m as=44p ps=0.20088m w=100u l=10u
X4 ITAIL SENSE IN2 VIN pfet_06v0 ad=44p pd=0.20088m as=44p ps=0.20088m w=100u l=10u
X5 VSS IN2 ICTRL VSS nfet_06v0 ad=8.8p pd=40.88u as=8.8p ps=40.88u w=20u l=1u
X6 VIN IPB IPB VIN pfet_06v0 ad=8.8p pd=40.88u as=8.8p ps=40.88u w=20u l=4u
X7 VIN ICTRL SENSE VIN pfet_06v0 ad=44p pd=0.20088m as=44p ps=0.20088m w=100u l=10u
X8 ITAIL VSET IN1 VIN pfet_06v0 ad=44p pd=0.20088m as=44p ps=0.20088m w=100u l=10u
X9 VIN IPB ITAIL VIN pfet_06v0 ad=8.8p pd=40.88u as=8.8p ps=40.88u w=20u l=4u
C0 SENSE ICTRL 5.76417f
C1 ITAIL SENSE 5.60938f
C2 IN1 VSET 5.60882f
C3 SENSE IN2 6.00496f
C4 ITAIL VSET 5.61115f
C5 VIN IOUT 14.0028f
C6 ITAIL IPB 1.3862f
C7 IN1 VIN 12.5609f
C8 VIN ICTRL 42.5399f
C9 ITAIL VIN 23.478f
C10 VIN IN2 12.0698f
C11 ICTRL IOUT 6.67402f
C12 VIN SENSE 16.3194f
C13 ITAIL IN1 0.69787f
C14 IN1 IN2 3.18532f
C15 VIN VSET 4.33749f
C16 IN2 ICTRL 1.15305f
C17 VIN IPB 12.2106f
C18 ITAIL IN2 0.16152f
C19 IN1 SENSE 0.06934f
C20 IOUT VSS 10.476f
C21 ICTRL VSS 40.325f
C22 IN2 VSS 26.7747f
C23 SENSE VSS 19.3839f
C24 VSET VSS 9.37871f
C25 IPB VSS 15.7424f
C26 VIN VSS 0.96755p
C27 IN1 VSS 45.2841f ; **FLOATING
C28 ITAIL VSS 21.5611f ; **FLOATING
