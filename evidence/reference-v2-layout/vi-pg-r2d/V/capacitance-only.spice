* Explicit control derived from full raw RC; original RC retained.
.subckt nrz_vi_reference VIN VSS VSET SENSE IOUT IPB IN2 ICTRL
X0 VSS IN1 IN2 VSS nfet_06v0 ad=22p pd=0.10088m as=22p ps=0.10088m w=50u l=10u
X1 VSS IN1 IN1 VSS nfet_06v0 ad=22p pd=0.10088m as=22p ps=0.10088m w=50u l=10u
X2 VIN ICTRL IOUT VIN pfet_06v0 ad=44p pd=0.20088m as=44p ps=0.20088m w=100u l=10u
X3 VIN ICTRL ICTRL VIN pfet_06v0 ad=44p pd=0.20088m as=44p ps=0.20088m w=100u l=10u
X4 ITAIL SENSE IN2 VIN pfet_06v0 ad=44p pd=0.20088m as=44p ps=0.20088m w=100u l=10u
X5 VSS IN2 ICTRL VSS nfet_06v0 ad=8.8p pd=40.88u as=8.8p ps=40.88u w=20u l=1u
X6 VIN IPB IPB VIN pfet_06v0 ad=8.8p pd=40.88u as=8.8p ps=40.88u w=20u l=4u
X7 VIN ICTRL SENSE VIN pfet_06v0 ad=44p pd=0.20088m as=44p ps=0.20088m w=100u l=10u
X8 ITAIL VSET IN1 VIN pfet_06v0 ad=44p pd=0.20088m as=44p ps=0.20088m w=100u l=10u
X9 VIN IPB ITAIL VIN pfet_06v0 ad=8.8p pd=40.88u as=8.8p ps=40.88u w=20u l=4u
C0 ICTRL VSS 1.3979960691e-18
C1 ICTRL VSS 3.50449827308e-15
C2 ICTRL VSS 1.7797784455e-15
C3 ICTRL VSS 3.44123546129e-16
C4 ICTRL VSS 2.45635144406e-16
C5 ICTRL VSS 1.09732170372e-14
C6 ICTRL VSS 1.08007278127e-15
C7 ICTRL VSS 3.65717386654e-16
C8 ICTRL VSS 1.10573423525e-14
C9 ICTRL VSS 1.09732170372e-14
C10 IN1 VSS 4.67095368263e-18
C11 IN1 VSS 4.93059439903e-15
C12 IN1 VSS 1.00641482511e-15
C13 IN1 VSS 3.00275593884e-16
C14 IN1 VSS 2.33498556276e-15
C15 IN1 VSS 1.12942074035e-15
C16 IN1 VSS 4.33731413387e-16
C17 IN1 VSS 1.65908657359e-14
C18 IN1 VSS 1.79045036525e-15
C19 IN1 VSS 1.67626904106e-14
C20 IN2 VSS 1.11706500068e-17
C21 IN2 VSS 7.28832326378e-15
C22 IN2 VSS 3.26241310222e-15
C23 IN2 VSS 5.10174207498e-15
C24 IN2 VSS 8.6656851003e-15
C25 IN2 VSS 2.44536580872e-15
C26 IOUT VSS 7.1288309269e-18
C27 IOUT VSS 3.35976759359e-15
C28 IOUT VSS 1.04108371938e-17
C29 IOUT VSS 1.90951479812e-17
C30 IOUT VSS 1.3495248221e-15
C31 IOUT VSS 5.83453144104e-18
C32 IOUT VSS 7.25615319292e-18
C33 IOUT VSS 5.92588124034e-18
C34 IOUT VSS 5.31485596047e-16
C35 IOUT VSS 3.4474948135e-16
C36 IOUT VSS 1.80121234055e-15
C37 IOUT VSS 3.03360878438e-15
C38 IPB VSS 5.92977490899e-18
C39 IPB VSS 3.95330291218e-15
C40 IPB VSS 9.6785058085e-16
C41 IPB VSS 4.552662207e-15
C42 IPB VSS 1.58930305098e-15
C43 IPB VSS 4.67335147408e-15
C44 ITAIL VSS 9.93538890779e-18
C45 ITAIL VSS 4.375331929e-15
C46 ITAIL VSS 1.27740881276e-16
C47 ITAIL VSS 1.89521691454e-15
C48 ITAIL VSS 1.63190188288e-15
C49 ITAIL VSS 6.78410594992e-15
C50 ITAIL VSS 6.55235277143e-15
C51 ITAIL VSS 1.84514282057e-16
C52 SENSE VSS 1.854178362e-18
C53 SENSE VSS 3.07244833799e-15
C54 SENSE VSS 1.71051818644e-15
C55 SENSE VSS 1.45990792972e-14
C56 VIN VSS 2.08726371893e-17
C57 VIN VSS 5.29683343002e-15
C58 VIN VSS 1.11870367094e-15
C59 VIN VSS 3.02074334966e-15
C60 VIN VSS 1.73503831815e-17
C61 VIN VSS 1.73503831815e-17
C62 VIN VSS 4.19315819294e-15
C63 VIN VSS 1.70829530452e-17
C64 VIN VSS 2.12453226489e-17
C65 VIN VSS 2.12453226489e-17
C66 VIN VSS 1.76178133178e-17
C67 VIN VSS 1.15814627405e-14
C68 VIN VSS 5.59087993585e-17
C69 VIN VSS 1.33028375668e-15
C70 VIN VSS 5.59087993585e-17
C71 VIN VSS 1.73503831815e-17
C72 VIN VSS 1.73503831815e-17
C73 VIN VSS 5.03178842437e-15
C74 VIN VSS 3.02074334966e-15
C75 VIN VSS 1.76178133178e-17
C76 VIN VSS 1.70829530452e-17
C77 VIN VSS 9.64971798324e-15
C78 VIN VSS 1.73503831815e-17
C79 VIN VSS 1.73503831815e-17
C80 VIN VSS 1.33028375668e-15
C81 VIN VSS 2.58649478316e-15
C82 VIN VSS 1.11311022295e-15
C83 VIN VSS 1.2598133477e-16
C84 VIN VSS 2.60879118153e-17
C85 VIN VSS 5.59087993585e-17
C86 VIN VSS 2.12453226489e-17
C87 VIN VSS 1.15817441718e-14
C88 VIN VSS 1.70829530452e-17
C89 VIN VSS 9.69087731756e-17
C90 VIN VSS 1.73503831815e-17
C91 VIN VSS 1.33028375668e-15
C92 VIN VSS 5.59087993585e-17
C93 VIN VSS 7.95521985045e-16
C94 VIN VSS 6.36307126233e-18
C95 VIN VSS 4.36100384755e-15
C96 VIN VSS 2.12453226489e-17
C97 VIN VSS 2.12453226489e-17
C98 VIN VSS 6.14996441154e-15
C99 VIN VSS 1.70829530452e-17
C100 VIN VSS 2.12453226489e-17
C101 VIN VSS 2.12453226489e-17
C102 VIN VSS 5.59087993585e-17
C103 VIN VSS 1.76178133178e-17
C104 VIN VSS 4.90411709437e-15
C105 VIN VSS 5.59087993585e-17
C106 VIN VSS 2.09197065818e-15
C107 VIN VSS 5.59087993585e-17
C108 VIN VSS 2.12453226489e-17
C109 VIN VSS 2.12453226489e-17
C110 VIN VSS 1.70829530452e-17
C111 VIN VSS 2.12453226489e-17
C112 VIN VSS 2.12453226489e-17
C113 VIN VSS 2.12453226489e-17
C114 VIN VSS 1.76178133178e-17
C115 VIN VSS 4.90411709437e-15
C116 VIN VSS 5.59087993585e-17
C117 VIN VSS 1.47125271777e-15
C118 VIN VSS 1.73503831815e-17
C119 VIN VSS 1.73503831815e-17
C120 VIN VSS 4.40561071585e-15
C121 VIN VSS 1.70829530452e-17
C122 VIN VSS 2.12453226489e-17
C123 VIN VSS 2.12453226489e-17
C124 VIN VSS 2.12453226489e-17
C125 VIN VSS 1.76178133178e-17
C126 VIN VSS 4.22316581018e-14
C127 VIN VSS 5.59087993585e-17
C128 VIN VSS 1.33028375668e-15
C129 VIN VSS 1.73503831815e-17
C130 VIN VSS 1.73503831815e-17
C131 VIN VSS 6.14996441154e-15
C132 VIN VSS 4.90411709437e-15
C133 VIN VSS 1.76178133178e-17
C134 VIN VSS 1.70829530452e-17
C135 VIN VSS 8.45342369028e-15
C136 VIN VSS 6.14996441154e-15
C137 VIN VSS 1.73503831815e-17
C138 VIN VSS 1.73503831815e-17
C139 VIN VSS 1.33028375668e-15
C140 VIN VSS 1.19324779865e-15
C141 VIN VSS 5.59087993585e-17
C142 VIN VSS 2.12453226489e-17
C143 VIN VSS 4.22316581018e-14
C144 VIN VSS 1.76178133178e-17
C145 VIN VSS 1.70829530452e-17
C146 VIN VSS 1.70829530452e-17
C147 VIN VSS 2.12453226489e-17
C148 VIN VSS 1.73503831815e-17
C149 VIN VSS 1.73503831815e-17
C150 VIN VSS 1.33028375668e-15
C151 VIN VSS 1.19324779865e-15
C152 VIN VSS 1.19324779865e-15
C153 VIN VSS 1.33028375668e-15
C154 VIN VSS 1.73503831815e-17
C155 VIN VSS 1.73503831815e-17
C156 VIN VSS 6.14996441154e-15
C157 VIN VSS 2.12453226489e-17
C158 VIN VSS 1.70829530452e-17
C159 VIN VSS 2.12453226489e-17
C160 VIN VSS 2.12453226489e-17
C161 VIN VSS 1.76178133178e-17
C162 VIN VSS 4.22316581018e-14
C163 VIN VSS 5.59087993585e-17
C164 VIN VSS 1.33028375668e-15
C165 VIN VSS 1.73503831815e-17
C166 VIN VSS 1.73503831815e-17
C167 VIN VSS 2.70486480718e-14
C168 VIN VSS 2.12453226489e-17
C169 VIN VSS 4.22316581018e-14
C170 VIN VSS 1.76178133178e-17
C171 VIN VSS 1.70829530452e-17
C172 VIN VSS 2.96316249632e-14
C173 VIN VSS 1.73503831815e-17
C174 VIN VSS 1.73503831815e-17
C175 VIN VSS 1.33028375668e-15
C176 VIN VSS 2.75869558784e-15
C177 VIN VSS 5.59087993585e-17
C178 VIN VSS 2.12453226489e-17
C179 VIN VSS 1.76178133178e-17
C180 VIN VSS 4.22316581018e-14
C181 VIN VSS 1.76178133178e-17
C182 VIN VSS 1.70829530452e-17
C183 VIN VSS 2.12453226489e-17
C184 VIN VSS 1.73503831815e-17
C185 VIN VSS 1.73503831815e-17
C186 VIN VSS 1.33028375668e-15
C187 VIN VSS 1.34681081246e-15
C188 VIN VSS 1.06279733411e-15
C189 VIN VSS 1.33028375668e-15
C190 VIN VSS 9.97779657456e-14
C191 VIN VSS 9.79268510689e-15
C192 VIN VSS 1.04183773463e-14
C193 VIN VSS 2.95426223001e-15
C194 VIN VSS 9.97779657456e-14
C195 VIN VSS 9.79268510689e-15
C196 VIN VSS 9.97779657456e-14
C197 VIN VSS 9.79268510689e-15
C198 VIN VSS 9.97779657456e-14
C199 VIN VSS 9.97779657456e-14
C200 VIN VSS 1.04183773463e-14
C201 VIN VSS 2.95426223001e-15
C202 VSET VSS 1.26722835778e-15
C203 VSET VSS 8.11148164222e-15
C204 IN1 IN2 3.18532e-15
C205 ITAIL VSET 5.61115e-15
C206 VIN SENSE 1.63194e-14
C207 SENSE IN2 6.00496e-15
C208 ITAIL IN1 6.97867e-16
C209 VIN IN2 1.20698e-14
C210 VIN IPB 1.22106e-14
C211 ICTRL IOUT 6.67402e-15
C212 ITAIL SENSE 5.60938e-15
C213 VSET IN1 5.60882e-15
C214 VIN ITAIL 2.3478e-14
C215 ICTRL SENSE 5.76417e-15
C216 ICTRL VIN 4.25399e-14
C217 ITAIL IN2 1.61524e-16
C218 IPB ITAIL 1.3862e-15
C219 VIN VSET 4.33749e-15
C220 ICTRL IN2 1.15305e-15
C221 IOUT VIN 1.40028e-14
C222 IN1 SENSE 6.93405e-17
C223 VIN IN1 1.25609e-14
.ends nrz_vi_reference
