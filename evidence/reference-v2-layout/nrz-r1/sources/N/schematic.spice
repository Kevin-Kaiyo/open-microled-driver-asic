* Independent electrical reference: layout/reference_v2/nrz_bias_power-reference.spice
.subckt nrz_bias_power VIN VSS VSET SENSE IOUT REGFB VREG IPB IN2 ICTRL LPB LN2 LCTRL
XIPBIAS IPB IPB VIN VIN pfet_06v0 w=20u l=4u
XIPTAIL ITAIL IPB VIN VIN pfet_06v0 w=20u l=4u
XIPD1 IN1 VSET ITAIL VIN pfet_06v0 w=100u l=10u
XIPD2 IN2 SENSE ITAIL VIN pfet_06v0 w=100u l=10u
XIND1 IN1 IN1 VSS VSS nfet_06v0 w=50u l=10u
XIND2 IN2 IN1 VSS VSS nfet_06v0 w=50u l=10u
XINSTAGE ICTRL IN2 VSS VSS nfet_06v0 w=20u l=1u
XIPLOAD ICTRL ICTRL VIN VIN pfet_06v0 w=100u l=10u
XIPREG SENSE ICTRL VIN VIN pfet_06v0 w=100u l=10u
XIPOUT IOUT ICTRL VIN VIN pfet_06v0 w=100u l=10u
XLPBIAS LPB LPB VIN VIN pfet_06v0 w=20u l=4u
XLPTAIL LTAIL LPB VIN VIN pfet_06v0 w=20u l=4u
XLPD1 LN1 VSET LTAIL VIN pfet_06v0 w=100u l=10u
XLPD2 LN2 REGFB LTAIL VIN pfet_06v0 w=100u l=10u
XLND1 LN1 LN1 VSS VSS nfet_06v0 w=50u l=10u
XLND2 LN2 LN1 VSS VSS nfet_06v0 w=50u l=10u
XLNSTAGE LCTRL LN2 VSS VSS nfet_06v0 w=20u l=1u
XLPLOAD LCTRL LCTRL VIN VIN pfet_06v0 w=100u l=10u
XLPREG VREG LCTRL VIN VIN pfet_06v0 w=100u l=10u
.ends nrz_bias_power
