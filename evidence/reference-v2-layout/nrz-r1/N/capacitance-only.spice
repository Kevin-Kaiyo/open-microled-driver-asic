* Explicit control derived from full raw RC; original RC retained.
.subckt nrz_bias_power VIN VSS VSET SENSE IOUT REGFB VREG IPB IN2 ICTRL LPB LN2 LCTRL
X0 VIN LPB LTAIL VIN pfet_06v0 ad=8.8p pd=40.88u as=8.8p ps=40.88u w=20u l=4u
X1 VIN LCTRL VREG VIN pfet_06v0 ad=44p pd=0.20088m as=44p ps=0.20088m w=100u l=10u
X2 VSS IN1 IN2 VSS nfet_06v0 ad=22p pd=0.10088m as=22p ps=0.10088m w=50u l=10u
X3 VSS IN1 IN1 VSS nfet_06v0 ad=22p pd=0.10088m as=22p ps=0.10088m w=50u l=10u
X4 VIN ICTRL IOUT VIN pfet_06v0 ad=44p pd=0.20088m as=44p ps=0.20088m w=100u l=10u
X5 VSS LN1 LN2 VSS nfet_06v0 ad=22p pd=0.10088m as=22p ps=0.10088m w=50u l=10u
X6 VIN ICTRL ICTRL VIN pfet_06v0 ad=44p pd=0.20088m as=44p ps=0.20088m w=100u l=10u
X7 VSS LN1 LN1 VSS nfet_06v0 ad=22p pd=0.10088m as=22p ps=0.10088m w=50u l=10u
X8 LTAIL VSET LN1 VIN pfet_06v0 ad=44p pd=0.20088m as=44p ps=0.20088m w=100u l=10u
X9 VIN LCTRL LCTRL VIN pfet_06v0 ad=44p pd=0.20088m as=44p ps=0.20088m w=100u l=10u
X10 VIN LPB LPB VIN pfet_06v0 ad=8.8p pd=40.88u as=8.8p ps=40.88u w=20u l=4u
X11 ITAIL SENSE IN2 VIN pfet_06v0 ad=44p pd=0.20088m as=44p ps=0.20088m w=100u l=10u
X12 VSS IN2 ICTRL VSS nfet_06v0 ad=8.8p pd=40.88u as=8.8p ps=40.88u w=20u l=1u
X13 VIN IPB IPB VIN pfet_06v0 ad=8.8p pd=40.88u as=8.8p ps=40.88u w=20u l=4u
X14 LTAIL REGFB LN2 VIN pfet_06v0 ad=44p pd=0.20088m as=44p ps=0.20088m w=100u l=10u
X15 VSS LN2 LCTRL VSS nfet_06v0 ad=8.8p pd=40.88u as=8.8p ps=40.88u w=20u l=1u
X16 VIN ICTRL SENSE VIN pfet_06v0 ad=44p pd=0.20088m as=44p ps=0.20088m w=100u l=10u
X17 ITAIL VSET IN1 VIN pfet_06v0 ad=44p pd=0.20088m as=44p ps=0.20088m w=100u l=10u
X18 VIN IPB ITAIL VIN pfet_06v0 ad=8.8p pd=40.88u as=8.8p ps=40.88u w=20u l=4u
C0 ICTRL VSS 1.42874654929e-18
C1 ICTRL VSS 3.57992695762e-15
C2 ICTRL VSS 1.81848217687e-15
C3 ICTRL VSS 3.42653690396e-16
C4 ICTRL VSS 2.4198877949e-16
C5 ICTRL VSS 1.11969641572e-14
C6 ICTRL VSS 1.09477391713e-15
C7 ICTRL VSS 3.64714362929e-16
C8 ICTRL VSS 1.12837030545e-14
C9 ICTRL VSS 1.11969641572e-14
C10 IN1 VSS 4.40828533849e-18
C11 IN1 VSS 4.58475646527e-15
C12 IN1 VSS 8.9005233643e-16
C13 IN1 VSS 2.83389177741e-16
C14 IN1 VSS 2.14382896298e-15
C15 IN1 VSS 1.00609748738e-15
C16 IN1 VSS 4.09341078441e-16
C17 IN1 VSS 1.55708741523e-14
C18 IN1 VSS 1.6298713597e-15
C19 IN1 VSS 1.57361806944e-14
C20 IN2 VSS 1.13818776146e-17
C21 IN2 VSS 7.24690123983e-15
C22 IN2 VSS 3.25209006531e-15
C23 IN2 VSS 5.12606918906e-15
C24 IN2 VSS 8.75739042605e-15
C25 IN2 VSS 2.45466720212e-15
C26 IOUT VSS 1.30173871395e-15
C27 IOUT VSS 4.48307128605e-15
C28 IPB VSS 6.33050937884e-18
C29 IPB VSS 4.13017263062e-15
C30 IPB VSS 9.93163846479e-16
C31 IPB VSS 4.82575062138e-15
C32 IPB VSS 1.65661862642e-15
C33 IPB VSS 4.95366376572e-15
C34 ITAIL VSS 9.61825673613e-18
C35 ITAIL VSS 3.97750514744e-15
C36 ITAIL VSS 1.23663061968e-16
C37 ITAIL VSS 1.70424446476e-15
C38 ITAIL VSS 1.44921936469e-15
C39 ITAIL VSS 6.43419212463e-15
C40 ITAIL VSS 6.21253297109e-15
C41 ITAIL VSS 1.78624608673e-16
C42 LCTRL VSS 1.5265091196e-18
C43 LCTRL VSS 3.7802444188e-15
C44 LCTRL VSS 3.51611273846e-16
C45 LCTRL VSS 2.44042111381e-16
C46 LCTRL VSS 1.19344111824e-14
C47 LCTRL VSS 1.15516045238e-15
C48 LCTRL VSS 3.75170181706e-16
C49 LCTRL VSS 1.20284338704e-14
C50 LN1 VSS 4.33254979923e-18
C51 LN1 VSS 4.48006194482e-15
C52 LN1 VSS 8.51271320943e-16
C53 LN1 VSS 2.78521204196e-16
C54 LN1 VSS 2.08348414128e-15
C55 LN1 VSS 9.65304144235e-16
C56 LN1 VSS 4.02308632664e-16
C57 LN1 VSS 1.52687001369e-14
C58 LN1 VSS 1.57832897205e-15
C59 LN1 VSS 1.54324869531e-14
C60 LN2 VSS 1.11556675779e-17
C61 LN2 VSS 6.8384044099e-15
C62 LN2 VSS 3.08157592601e-15
C63 LN2 VSS 4.91810633604e-15
C64 LN2 VSS 8.47725054091e-15
C65 LN2 VSS 2.35250711956e-15
C66 LPB VSS 6.12236500527e-18
C67 LPB VSS 3.86284963093e-15
C68 LPB VSS 9.02347062506e-16
C69 LPB VSS 4.61724583124e-15
C70 LPB VSS 1.5439941555e-15
C71 LPB VSS 4.73954095482e-15
C72 LTAIL VSS 9.35858524543e-18
C73 LTAIL VSS 3.76973367059e-15
C74 LTAIL VSS 1.20324285624e-16
C75 LTAIL VSS 1.60745445525e-15
C76 LTAIL VSS 1.35926025872e-15
C77 LTAIL VSS 6.20851654091e-15
C78 LTAIL VSS 1.73801686508e-16
C79 LTAIL VSS 5.99395051715e-15
C80 REGFB VSS 1.23508172576e-15
C81 REGFB VSS 7.89305827424e-15
C82 SENSE VSS 1.86306564859e-18
C83 SENSE VSS 3.0871848502e-15
C84 SENSE VSS 1.71872057298e-15
C85 SENSE VSS 1.46690315112e-14
C86 VIN VSS 1.33359828265e-17
C87 VIN VSS 3.50569371029e-14
C88 VIN VSS 3.65010288088e-15
C89 VIN VSS 3.18008908023e-14
C90 VIN VSS 3.65010288088e-15
C91 VIN VSS 3.18008908023e-14
C92 VIN VSS 3.65010288088e-15
C93 VIN VSS 3.34625157344e-14
C94 VIN VSS 3.36679388635e-14
C95 VIN VSS 3.1984037333e-14
C96 VIN VSS 2.66211331465e-15
C97 VIN VSS 1.07239395307e-14
C98 VIN VSS 2.72879360255e-15
C99 VIN VSS 3.34625157344e-14
C100 VIN VSS 1.04830084008e-14
C101 VIN VSS 3.36679388635e-14
C102 VIN VSS 3.1984037333e-14
C103 VIN VSS 2.66211331465e-15
C104 VIN VSS 1.07239395307e-14
C105 VIN VSS 2.72879360255e-15
C106 VIN VSS 1.07461413755e-14
C107 VIN VSS 3.71678316878e-15
C108 VIN VSS 1.34091666851e-13
C109 VIN VSS 1.08099062696e-14
C110 VIN VSS 1.05990261214e-14
C111 VIN VSS 1.34091666851e-13
C112 VIN VSS 1.05990261214e-14
C113 VIN VSS 1.34091666851e-13
C114 VIN VSS 1.05990261214e-14
C115 VIN VSS 1.34091666851e-13
C116 VIN VSS 1.34091666851e-13
C117 VIN VSS 1.34091666851e-13
C118 VIN VSS 1.47050218317e-14
C119 VIN VSS 3.7854818062e-15
C120 VIN VSS 1.34091666851e-13
C121 VIN VSS 1.47050218317e-14
C122 VIN VSS 3.7854818062e-15
C123 VIN VSS 1.05990261214e-14
C124 VIN VSS 1.34091666851e-13
C125 VIN VSS 1.47050218317e-14
C126 VIN VSS 3.7854818062e-15
C127 VIN VSS 1.47050218317e-14
C128 VIN VSS 3.7854818062e-15
C129 VIN VSS 1.34091666851e-13
C130 VREG VSS 1.24141739434e-15
C131 VREG VSS 4.36210260566e-15
C132 VSET VSS 1.48459454529e-18
C133 VSET VSS 3.94302146799e-15
C134 VSET VSS 1.24368065131e-14
C135 VSET VSS 1.16980874244e-14
C136 IN1 SENSE 6.93405e-17
C137 REGFB LN2 5.60713e-15
C138 VIN IN1 1.10109e-14
C139 ICTRL SENSE 5.60808e-15
C140 REGFB VIN 3.75099e-15
C141 ICTRL IOUT 5.60766e-15
C142 ICTRL VIN 3.926e-14
C143 IN1 IN2 2.95002e-15
C144 LTAIL LN1 6.97867e-16
C145 LN2 VIN 1.10138e-14
C146 LTAIL VSET 5.59562e-15
C147 ICTRL IN2 1.15199e-15
C148 ITAIL VSET 5.60006e-15
C149 VIN SENSE 1.5138e-14
C150 IOUT VIN 1.11689e-14
C151 LN2 LCTRL 1.11915e-15
C152 SENSE IN2 5.61384e-15
C153 LTAIL REGFB 5.59502e-15
C154 ITAIL IN1 6.97867e-16
C155 VIN IN2 1.10803e-14
C156 LN1 VSET 5.5933e-15
C157 LCTRL VIN 2.97513e-14
C158 LPB VIN 9.4247e-15
C159 VIN IPB 9.57555e-15
C160 LN1 REGFB 6.93405e-17
C161 LTAIL LN2 1.13766e-16
C162 VREG VIN 1.11245e-14
C163 ITAIL SENSE 5.59951e-15
C164 VSET IN1 5.59773e-15
C165 LTAIL VIN 2.26685e-14
C166 VIN ITAIL 2.27341e-14
C167 LCTRL VREG 5.601e-15
C168 LN1 LN2 2.94559e-15
C169 VSET SENSE 1.71377e-15
C170 ITAIL IN2 6.35262e-17
C171 IOUT VSET 8.81646e-18
C172 LN1 VIN 1.09666e-14
C173 LPB LTAIL 1.32706e-15
C174 IPB ITAIL 1.34064e-15
C175 VIN VSET 8.61431e-15
.ends nrz_bias_power
