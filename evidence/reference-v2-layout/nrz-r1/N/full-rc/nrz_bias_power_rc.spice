* Audited RC model assembly from build/reference-v2-layout/nrz-r1/N/readback/nrz_bias_power.ext.
* Original Magic RC preserved in ../unmodified-full-rc/.
* R/MOS unchanged; C counted once with post-simplification allocation weights.
* Coupling remains at original logical nodes; no EM claim.
.subckt nrz_bias_power VIN VSS VSET SENSE IOUT REGFB VREG IPB IN2 ICTRL LPB LN2 LCTRL
X0 VIN.t8 LPB.t2 LTAIL.t1 VIN.t7 pfet_06v0 ad=8.8p pd=40.88u as=8.8p ps=40.88u w=20u l=4u
X1 VIN.t1 LCTRL.t3 VREG.t0 VIN.t0 pfet_06v0 ad=44p pd=0.20088m as=44p ps=0.20088m w=100u l=10u
X2 VSS.t7 IN1.t3 IN2.t0 VSS.t6 nfet_06v0 ad=22p pd=0.10088m as=22p ps=0.10088m w=50u l=10u
X3 VSS.t5 IN1.t1 IN1.t2 VSS.t4 nfet_06v0 ad=22p pd=0.10088m as=22p ps=0.10088m w=50u l=10u
X4 VIN.t12 ICTRL.t3 IOUT.t0 VIN.t11 pfet_06v0 ad=44p pd=0.20088m as=44p ps=0.20088m w=100u l=10u
X5 VSS.t11 LN1.t3 LN2.t0 VSS.t10 nfet_06v0 ad=22p pd=0.10088m as=22p ps=0.10088m w=50u l=10u
X6 VIN.t14 ICTRL.t0 ICTRL.t1 VIN.t13 pfet_06v0 ad=44p pd=0.20088m as=44p ps=0.20088m w=100u l=10u
X7 VSS.t9 LN1.t1 LN1.t2 VSS.t8 nfet_06v0 ad=22p pd=0.10088m as=22p ps=0.10088m w=50u l=10u
X8 LTAIL.t2 VSET.t0 LN1.t0 VIN.t16 pfet_06v0 ad=44p pd=0.20088m as=44p ps=0.20088m w=100u l=10u
X9 VIN.t3 LCTRL.t0 LCTRL.t1 VIN.t2 pfet_06v0 ad=44p pd=0.20088m as=44p ps=0.20088m w=100u l=10u
X10 VIN.t6 LPB.t0 LPB.t1 VIN.t5 pfet_06v0 ad=8.8p pd=40.88u as=8.8p ps=40.88u w=20u l=4u
X11 ITAIL.t0 SENSE.t1 IN2.t1 VIN.t15 pfet_06v0 ad=44p pd=0.20088m as=44p ps=0.20088m w=100u l=10u
X12 VSS.t3 IN2.t2 ICTRL.t2 VSS.t2 nfet_06v0 ad=8.8p pd=40.88u as=8.8p ps=40.88u w=20u l=1u
X13 VIN.t19 IPB.t0 IPB.t1 VIN.t18 pfet_06v0 ad=8.8p pd=40.88u as=8.8p ps=40.88u w=20u l=4u
X14 LTAIL.t0 REGFB.t0 LN2.t1 VIN.t4 pfet_06v0 ad=44p pd=0.20088m as=44p ps=0.20088m w=100u l=10u
X15 VSS.t1 LN2.t2 LCTRL.t2 VSS.t0 nfet_06v0 ad=8.8p pd=40.88u as=8.8p ps=40.88u w=20u l=1u
X16 VIN.t10 ICTRL.t4 SENSE.t0 VIN.t9 pfet_06v0 ad=44p pd=0.20088m as=44p ps=0.20088m w=100u l=10u
X17 ITAIL.t1 VSET.t1 IN1.t0 VIN.t17 pfet_06v0 ad=44p pd=0.20088m as=44p ps=0.20088m w=100u l=10u
X18 VIN.t21 IPB.t2 ITAIL.t2 VIN.t20 pfet_06v0 ad=8.8p pd=40.88u as=8.8p ps=40.88u w=20u l=4u
R0 VREG VREG.t0 41.5805
R1 LCTRL.n0 LCTRL.t3 101.763
R2 LCTRL.n0 LCTRL.t0 96.8122
R3 LCTRL.n1 LCTRL.t1 38.6484
R4 LCTRL.n2 LCTRL.t2 29.364
R5 LCTRL.n2 LCTRL.n1 3.038
R6 LCTRL.n1 LCTRL.n0 1.184
R7 LCTRL LCTRL.n2 0.0905
R8 LN2.n0 LN2.t2 127.876
R9 LN2.n1 LN2.t1 39.1221
R10 LN2.n0 LN2.t0 33.2506
R11 LN2.n1 LN2.n0 9.9005
R12 LN2 LN2.n1 0.0905
R13 REGFB REGFB.t0 100.219
R14 LPB.n0 LPB.t2 65.7788
R15 LPB.n0 LPB.t0 61.7288
R16 LPB.n1 LPB.t1 30.2943
R17 LPB.n1 LPB.n0 0.509
R18 LPB LPB.n1 0.0905
R19 IOUT IOUT.t0 42.5279
R20 ICTRL.n0 ICTRL.t3 103.183
R21 ICTRL.n0 ICTRL.t4 98.2333
R22 ICTRL.n1 ICTRL.t0 98.2333
R23 ICTRL.n2 ICTRL.t1 40.0694
R24 ICTRL.n3 ICTRL.t2 30.785
R25 ICTRL.n1 ICTRL.n0 4.9505
R26 ICTRL.n3 ICTRL.n2 3.038
R27 ICTRL.n2 ICTRL.n1 1.184
R28 ICTRL ICTRL.n3 0.0905
R29 IN2.n0 IN2.t2 129.298
R30 IN2.n1 IN2.t1 40.5431
R31 IN2.n0 IN2.t0 34.6716
R32 IN2.n1 IN2.n0 9.9005
R33 IN2 IN2.n1 0.0905
R34 SENSE.n0 SENSE.t1 101.076
R35 SENSE.n0 SENSE.t0 65.578
R36 SENSE SENSE.n0 0.0905
R37 VSET.n0 VSET.t0 148.35
R38 VSET.n0 VSET.t1 101.549
R39 VSET VSET.n0 0.0905
R40 IPB.n0 IPB.t2 67.1998
R41 IPB.n0 IPB.t0 63.1498
R42 IPB.n1 IPB.t1 31.7153
R43 IPB.n1 IPB.n0 0.509
R44 IPB IPB.n1 0.0905
R45 VIN.n20 VIN.t18 131.619
R46 VIN.n18 VIN.t20 131.619
R47 VIN.n8 VIN.t5 131.619
R48 VIN.n6 VIN.t7 131.619
R49 VIN.n2 VIN.t2 99.7359
R50 VIN.n10 VIN.t11 99.7359
R51 VIN.n3 VIN.t4 99.7359
R52 VIN.n4 VIN.t16 99.7359
R53 VIN.n15 VIN.t15 99.7359
R54 VIN.n14 VIN.t13 99.7359
R55 VIN.n0 VIN.t0 99.7359
R56 VIN.n12 VIN.t9 99.7359
R57 VIN.n16 VIN.t17 99.7359
R58 VIN.n0 VIN.t1 47.2036
R59 VIN.n11 VIN.t10 44.3326
R60 VIN.n1 VIN.t3 44.3326
R61 VIN.n13 VIN.t14 44.3326
R62 VIN.n9 VIN.t12 44.3326
R63 VIN.n7 VIN.t6 35.0311
R64 VIN.n17 VIN.t21 35.0311
R65 VIN.n19 VIN.t19 35.0311
R66 VIN.n5 VIN.t8 35.0311
R67 VIN.n3 VIN.n2 18.9005
R68 VIN.n15 VIN.n14 18.9005
R69 VIN.n16 VIN.n15 4.9505
R70 VIN.n4 VIN.n3 4.9505
R71 VIN.n10 VIN.n9 2.8715
R72 VIN.n12 VIN.n11 2.8715
R73 VIN.n2 VIN.n1 2.8715
R74 VIN.n14 VIN.n13 2.8715
R75 VIN.n9 VIN.n8 2.7545
R76 VIN.n7 VIN.n6 2.5295
R77 VIN.n19 VIN.n18 2.5295
R78 VIN.n11 VIN.n10 2.0795
R79 VIN.n13 VIN.n12 2.0795
R80 VIN.n1 VIN.n0 2.0795
R81 VIN.n5 VIN.n4 1.8545
R82 VIN.n17 VIN.n16 1.8545
R83 VIN.n18 VIN.n17 1.5215
R84 VIN.n6 VIN.n5 1.5215
R85 VIN.n8 VIN.n7 1.5215
R86 VIN.n20 VIN.n19 1.5215
R87 VIN VIN.n20 0.0905
R88 VSS.n8 VSS.n2 6840.6
R89 VSS.n20 VSS.n7 621.611
R90 VSS.n34 VSS.n33 621.611
R91 VSS.n11 VSS.n10 621.444
R92 VSS.n11 VSS.n9 621.444
R93 VSS.n33 VSS.n1 621.444
R94 VSS.n35 VSS.n1 621.444
R95 VSS.n7 VSS.n6 621.444
R96 VSS.n17 VSS.n9 621.444
R97 VSS.n17 VSS.n10 621.444
R98 VSS.n30 VSS.n4 621.444
R99 VSS.n24 VSS.n4 621.444
R100 VSS.n24 VSS.n3 621.444
R101 VSS.n21 VSS.n6 621.444
R102 VSS.n30 VSS.n3 621.444
R103 VSS.n26 VSS.n25 458.818
R104 VSS.n13 VSS.n12 458.818
R105 VSS.n32 VSS.n31 316.796
R106 VSS.n19 VSS.n18 316.796
R107 VSS.t8 VSS.n19 188.69
R108 VSS.n12 VSS.t10 188.69
R109 VSS.n32 VSS.t4 188.69
R110 VSS.n25 VSS.t6 188.69
R111 VSS.n21 VSS.n20 144.732
R112 VSS.n35 VSS.n34 144.732
R113 VSS.n31 VSS.n2 125.584
R114 VSS.n18 VSS.n8 125.584
R115 VSS.t10 VSS.n8 63.1073
R116 VSS.t6 VSS.n2 63.1073
R117 VSS.n22 VSS.n21 38.3025
R118 VSS.n36 VSS.n35 38.3025
R119 VSS.n30 VSS.n29 38.3025
R120 VSS.n17 VSS.n16 38.3025
R121 VSS.n5 VSS.t9 37.9874
R122 VSS.n15 VSS.t11 37.9874
R123 VSS.n0 VSS.t5 37.9874
R124 VSS.n28 VSS.t7 37.9874
R125 VSS.n14 VSS.t1 35.533
R126 VSS.n23 VSS.n22 35.042
R127 VSS.n27 VSS.n26 35.0162
R128 VSS.n14 VSS.n13 35.0162
R129 VSS.n23 VSS.t3 34.5745
R130 VSS.n13 VSS.t0 33.7241
R131 VSS.n26 VSS.t2 33.7241
R132 VSS.n15 VSS.n14 2.9795
R133 VSS.n28 VSS.n27 2.9795
R134 VSS.n16 VSS.n15 2.8715
R135 VSS.n22 VSS.n5 2.8715
R136 VSS.n29 VSS.n28 2.8715
R137 VSS.n36 VSS.n0 2.8715
R138 VSS.n16 VSS.n5 2.0795
R139 VSS.n29 VSS.n0 2.0795
R140 VSS.n27 VSS.n23 0.959
R141 VSS.t6 VSS.n3 0.217167
R142 VSS.t8 VSS.n6 0.217167
R143 VSS.t6 VSS.n4 0.217167
R144 VSS.t4 VSS.n1 0.217167
R145 VSS.t10 VSS.n9 0.217167
R146 VSS.t10 VSS.n10 0.217167
R147 VSS VSS.n36 0.0905
R148 VSS.n20 VSS.t8 0.0514603
R149 VSS.n34 VSS.t4 0.0514603
R150 VSS.n12 VSS.n11 0.0477727
R151 VSS.n33 VSS.n32 0.0477727
R152 VSS.n18 VSS.n17 0.0477727
R153 VSS.n25 VSS.n24 0.0477727
R154 VSS.n19 VSS.n7 0.0477727
R155 VSS.n31 VSS.n30 0.0477727
R156 LN1.n0 LN1.t3 69.7754
R157 LN1.n0 LN1.t1 64.8254
R158 LN1.n4 LN1.n3 36.7354
R159 LN1.n1 LN1.t2 30.8822
R160 LN1.n4 LN1.n1 9.9005
R161 LN1.n1 LN1.n0 1.184
R162 LN1 LN1.n4 0.068
R163 LN1.n3 LN1.t0 0.0187
R164 LN1.n3 LN1.n2 0.0131
R165 LTAIL.n0 LTAIL.t0 42.1773
R166 LTAIL.n0 LTAIL.t2 37.2273
R167 LTAIL.n3 LTAIL.n2 27.8348
R168 LTAIL.n3 LTAIL.n0 5.7425
R169 LTAIL.n2 LTAIL.t1 0.0915
R170 LTAIL LTAIL.n3 0.068
R171 LTAIL.n2 LTAIL.n1 0.0635
R172 IN1.n0 IN1.t3 70.7228
R173 IN1.n0 IN1.t1 65.7728
R174 IN1.n4 IN1.n3 37.6828
R175 IN1.n1 IN1.t2 31.8295
R176 IN1.n4 IN1.n1 9.9005
R177 IN1.n1 IN1.n0 1.184
R178 IN1 IN1.n4 0.068
R179 IN1.n3 IN1.t0 0.0187
R180 IN1.n3 IN1.n2 0.0131
R181 ITAIL.n0 ITAIL.t0 43.1247
R182 ITAIL.n0 ITAIL.t1 38.1747
R183 ITAIL.n3 ITAIL.n2 28.7822
R184 ITAIL.n3 ITAIL.n0 5.7425
R185 ITAIL.n2 ITAIL.t2 0.0915
R186 ITAIL ITAIL.n3 0.068
R187 ITAIL.n2 ITAIL.n1 0.0635
C0 ICTRL VSS 1.4287465492908098e-18
C1 ICTRL.n0 VSS 3.5799269576235632e-15
C2 ICTRL.n1 VSS 1.8184821768669264e-15
C3 ICTRL.n2 VSS 3.4265369039589974e-16
C4 ICTRL.n3 VSS 2.4198877948956246e-16
C5 ICTRL.t0 VSS 1.1196964157235233e-14
C6 ICTRL.t1 VSS 1.0947739171298778e-15
C7 ICTRL.t2 VSS 3.6471436292860033e-16
C8 ICTRL.t3 VSS 1.1283703054545812e-14
C9 ICTRL.t4 VSS 1.1196964157235233e-14
C10 IN1 VSS 4.4082853384902153e-18
C11 IN1.n0 VSS 4.5847564652687434e-15
C12 IN1.n1 VSS 8.9005233642956635e-16
C13 IN1.n2 VSS 2.8338917774121237e-16
C14 IN1.n3 VSS 2.1438289629792608e-15
C15 IN1.n4 VSS 1.0060974873752586e-15
C16 IN1.t0 VSS 4.0934107844067079e-16
C17 IN1.t1 VSS 1.5570874152333175e-14
C18 IN1.t2 VSS 1.6298713596991836e-15
C19 IN1.t3 VSS 1.573618069439445e-14
C20 IN2 VSS 1.1381877614569931e-17
C21 IN2.n0 VSS 7.2469012398282351e-15
C22 IN2.n1 VSS 3.2520900653148182e-15
C23 IN2.t0 VSS 5.126069189064726e-15
C24 IN2.t1 VSS 8.7573904260531853e-15
C25 IN2.t2 VSS 2.4546672021244677e-15
C26 IOUT VSS 1.3017387139507286e-15
C27 IOUT.t0 VSS 4.483071286049272e-15
C28 IPB VSS 6.3305093788412297e-18
C29 IPB.n0 VSS 4.1301726306248379e-15
C30 IPB.n1 VSS 9.9316384647930456e-16
C31 IPB.t0 VSS 4.8257506213778787e-15
C32 IPB.t1 VSS 1.6566186264193163e-15
C33 IPB.t2 VSS 4.953663765719824e-15
C34 ITAIL VSS 9.6182567361260042e-18
C35 ITAIL.n0 VSS 3.9775051474416565e-15
C36 ITAIL.n1 VSS 1.2366306196754538e-16
C37 ITAIL.n2 VSS 1.7042444647621806e-15
C38 ITAIL.n3 VSS 1.4492193646943164e-15
C39 ITAIL.t0 VSS 6.434192124632727e-15
C40 ITAIL.t1 VSS 6.2125329710924874e-15
C41 ITAIL.t2 VSS 1.7862460867295697e-16
C42 LCTRL VSS 1.5265091196026486e-18
C43 LCTRL.n0 VSS 3.7802444187962386e-15
C44 LCTRL.n1 VSS 3.5161127384632408e-16
C45 LCTRL.n2 VSS 2.4404211138140656e-16
C46 LCTRL.t0 VSS 1.1934411182351445e-14
C47 LCTRL.t1 VSS 1.155160452378511e-15
C48 LCTRL.t2 VSS 3.7517018170610296e-16
C49 LCTRL.t3 VSS 1.202843387042037e-14
C50 LN1 VSS 4.3325497992302652e-18
C51 LN1.n0 VSS 4.4800619448242119e-15
C52 LN1.n1 VSS 8.512713209427215e-16
C53 LN1.n2 VSS 2.7852120419568858e-16
C54 LN1.n3 VSS 2.0834841412799151e-15
C55 LN1.n4 VSS 9.6530414423513049e-16
C56 LN1.t0 VSS 4.0230863266403921e-16
C57 LN1.t1 VSS 1.5268700136928338e-14
C58 LN1.t2 VSS 1.5783289720451976e-15
C59 LN1.t3 VSS 1.5432486953085534e-14
C60 LN2 VSS 1.1155667577878078e-17
C61 LN2.n0 VSS 6.8384044098965315e-15
C62 LN2.n1 VSS 3.0815759260124353e-15
C63 LN2.t0 VSS 4.9181063360427633e-15
C64 LN2.t1 VSS 8.4772505409083009e-15
C65 LN2.t2 VSS 2.3525071195620912e-15
C66 LPB VSS 6.1223650052702665e-18
C67 LPB.n0 VSS 3.8628496309280658e-15
C68 LPB.n1 VSS 9.0234706250566964e-16
C69 LPB.t0 VSS 4.6172458312408173e-15
C70 LPB.t1 VSS 1.5439941555043617e-15
C71 LPB.t2 VSS 4.7395409548158155e-15
C72 LTAIL VSS 9.3585852454334771e-18
C73 LTAIL.n0 VSS 3.7697336705919596e-15
C74 LTAIL.n1 VSS 1.2032428562403411e-16
C75 LTAIL.n2 VSS 1.6074544552540202e-15
C76 LTAIL.n3 VSS 1.3592602587161041e-15
C77 LTAIL.t0 VSS 6.2085165409086147e-15
C78 LTAIL.t1 VSS 1.7380168650758759e-16
C79 LTAIL.t2 VSS 5.9939505171522463e-15
C80 REGFB VSS 1.2350817257557319e-15
C81 REGFB.t0 VSS 7.8930582742442673e-15
C82 SENSE VSS 1.8630656485907573e-18
C83 SENSE.n0 VSS 3.087184850204121e-15
C84 SENSE.t0 VSS 1.7187205729808444e-15
C85 SENSE.t1 VSS 1.4669031511166443e-14
C86 VIN VSS 1.3335982826501359e-17
C87 VIN.n0 VSS 3.5056937102859523e-14
C88 VIN.n1 VSS 3.650102880876793e-15
C89 VIN.n10 VSS 3.1800890802297754e-14
C90 VIN.n11 VSS 3.650102880876793e-15
C91 VIN.n12 VSS 3.1800890802297754e-14
C92 VIN.n13 VSS 3.650102880876793e-15
C93 VIN.n14 VSS 3.3462515734430069e-14
C94 VIN.n15 VSS 3.3667938863523986e-14
C95 VIN.n16 VSS 3.198403733296737e-14
C96 VIN.n17 VSS 2.6621133146531154e-15
C97 VIN.n18 VSS 1.0723939530722737e-14
C98 VIN.n19 VSS 2.728793602554052e-15
C99 VIN.n2 VSS 3.3462515734430069e-14
C100 VIN.n20 VSS 1.0483008400784709e-14
C101 VIN.n3 VSS 3.3667938863523986e-14
C102 VIN.n4 VSS 3.198403733296737e-14
C103 VIN.n5 VSS 2.6621133146531154e-15
C104 VIN.n6 VSS 1.0723939530722737e-14
C105 VIN.n7 VSS 2.728793602554052e-15
C106 VIN.n8 VSS 1.0746141375461054e-14
C107 VIN.n9 VSS 3.7167831687777293e-15
C108 VIN.t0 VSS 1.3409166685083218e-13
C109 VIN.t1 VSS 1.0809906269608474e-14
C110 VIN.t10 VSS 1.0599026121437461e-14
C111 VIN.t11 VSS 1.3409166685083218e-13
C112 VIN.t12 VSS 1.0599026121437461e-14
C113 VIN.t13 VSS 1.3409166685083218e-13
C114 VIN.t14 VSS 1.0599026121437461e-14
C115 VIN.t15 VSS 1.3409166685083218e-13
C116 VIN.t16 VSS 1.3409166685083218e-13
C117 VIN.t17 VSS 1.3409166685083218e-13
C118 VIN.t18 VSS 1.4705021831678216e-14
C119 VIN.t19 VSS 3.7854818062003313e-15
C120 VIN.t2 VSS 1.3409166685083218e-13
C121 VIN.t20 VSS 1.4705021831678216e-14
C122 VIN.t21 VSS 3.7854818062003313e-15
C123 VIN.t3 VSS 1.0599026121437461e-14
C124 VIN.t4 VSS 1.3409166685083218e-13
C125 VIN.t5 VSS 1.4705021831678216e-14
C126 VIN.t6 VSS 3.7854818062003313e-15
C127 VIN.t7 VSS 1.4705021831678216e-14
C128 VIN.t8 VSS 3.7854818062003313e-15
C129 VIN.t9 VSS 1.3409166685083218e-13
C130 VREG VSS 1.2414173943395448e-15
C131 VREG.t0 VSS 4.3621026056604556e-15
C132 VSET VSS 1.4845945452887615e-18
C133 VSET.n0 VSS 3.943021467985256e-15
C134 VSET.t0 VSS 1.2436806513060358e-14
C135 VSET.t1 VSS 1.1698087424409097e-14
C136 IN1 SENSE 6.9340500000000005e-17
C137 REGFB LN2 5.6071300000000008e-15
C138 VIN IN1 1.1010900000000001e-14
C139 ICTRL SENSE 5.6080800000000002e-15
C140 REGFB VIN 3.7509899999999998e-15
C141 ICTRL IOUT 5.6076600000000001e-15
C142 ICTRL VIN 3.9260000000000001e-14
C143 IN1 IN2 2.9500200000000002e-15
C144 LTAIL LN1 6.9786699999999999e-16
C145 LN2 VIN 1.1013800000000001e-14
C146 LTAIL VSET 5.59562e-15
C147 ICTRL IN2 1.15199e-15
C148 ITAIL VSET 5.6000600000000005e-15
C149 VIN SENSE 1.5138000000000003e-14
C150 IOUT VIN 1.1168900000000001e-14
C151 LN2 LCTRL 1.1191500000000002e-15
C152 SENSE IN2 5.6138400000000005e-15
C153 LTAIL REGFB 5.5950200000000007e-15
C154 ITAIL IN1 6.9786699999999999e-16
C155 VIN IN2 1.10803e-14
C156 LN1 VSET 5.5933000000000004e-15
C157 LCTRL VIN 2.9751299999999999e-14
C158 LPB VIN 9.4247000000000019e-15
C159 VIN IPB 9.57555e-15
C160 LN1 REGFB 6.9340500000000005e-17
C161 LTAIL LN2 1.13766e-16
C162 VREG VIN 1.11245e-14
C163 ITAIL SENSE 5.5995100000000009e-15
C164 VSET IN1 5.5977300000000003e-15
C165 LTAIL VIN 2.2668500000000001e-14
C166 VIN ITAIL 2.2734100000000002e-14
C167 LCTRL VREG 5.6010000000000001e-15
C168 LN1 LN2 2.9455900000000002e-15
C169 VSET SENSE 1.71377e-15
C170 ITAIL IN2 6.3526200000000013e-17
C171 IOUT VSET 8.8164600000000003e-18
C172 LN1 VIN 1.0966600000000001e-14
C173 LPB LTAIL 1.3270600000000001e-15
C174 IPB ITAIL 1.3406400000000002e-15
C175 VIN VSET 8.6143099999999994e-15
.ends nrz_bias_power
