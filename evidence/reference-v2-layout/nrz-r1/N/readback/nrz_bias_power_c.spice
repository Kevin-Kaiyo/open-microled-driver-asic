* NGSPICE file created from nrz_bias_power.ext - technology: gf180mcuD

.subckt nrz_bias_power VIN VSS VSET SENSE IOUT REGFB VREG IPB IN2 ICTRL LPB LN2 LCTRL
X0 VIN LPB LTAIL VIN pfet_06v0 ad=8.8p pd=40.88u as=8.8p ps=40.88u w=20u l=4u
X1 VIN LCTRL VREG VIN pfet_06v0 ad=44p pd=0.20088m as=44p ps=0.20088m w=100u l=10u
X2 VSS IN1 IN2 VSS nfet_06v0 ad=22p pd=0.10088m as=22p ps=0.10088m w=50u l=10u
X3 VSS IN1 IN1 VSS nfet_06v0 ad=22p pd=0.10088m as=22p ps=0.10088m w=50u l=10u
X4 VIN ICTRL IOUT VIN pfet_06v0 ad=44p pd=0.20088m as=44p ps=0.20088m w=100u l=10u
X5 VSS LN1 LN2 VSS nfet_06v0 ad=22p pd=0.10088m as=22p ps=0.10088m w=50u l=10u
X6 VIN ICTRL ICTRL VIN pfet_06v0 ad=44p pd=0.20088m as=44p ps=0.20088m w=100u l=10u
X7 VSS LN1 LN1 VSS nfet_06v0 ad=22p pd=0.10088m as=22p ps=0.10088m w=50u l=10u
X8 LTAIL VSET LN1 VIN pfet_06v0 ad=44p pd=0.20088m as=44p ps=0.20088m w=100u l=10u
X9 VIN LCTRL LCTRL VIN pfet_06v0 ad=44p pd=0.20088m as=44p ps=0.20088m w=100u l=10u
X10 VIN LPB LPB VIN pfet_06v0 ad=8.8p pd=40.88u as=8.8p ps=40.88u w=20u l=4u
X11 ITAIL SENSE IN2 VIN pfet_06v0 ad=44p pd=0.20088m as=44p ps=0.20088m w=100u l=10u
X12 VSS IN2 ICTRL VSS nfet_06v0 ad=8.8p pd=40.88u as=8.8p ps=40.88u w=20u l=1u
X13 VIN IPB IPB VIN pfet_06v0 ad=8.8p pd=40.88u as=8.8p ps=40.88u w=20u l=4u
X14 LTAIL REGFB LN2 VIN pfet_06v0 ad=44p pd=0.20088m as=44p ps=0.20088m w=100u l=10u
X15 VSS LN2 LCTRL VSS nfet_06v0 ad=8.8p pd=40.88u as=8.8p ps=40.88u w=20u l=1u
X16 VIN ICTRL SENSE VIN pfet_06v0 ad=44p pd=0.20088m as=44p ps=0.20088m w=100u l=10u
X17 ITAIL VSET IN1 VIN pfet_06v0 ad=44p pd=0.20088m as=44p ps=0.20088m w=100u l=10u
X18 VIN IPB ITAIL VIN pfet_06v0 ad=8.8p pd=40.88u as=8.8p ps=40.88u w=20u l=4u
C0 SENSE IN2 5.61384f
C1 VIN LPB 9.4247f
C2 LN1 LN2 2.94559f
C3 IN1 SENSE 0.06934f
C4 LTAIL VSET 5.59562f
C5 ITAIL IN2 0.06353f
C6 ITAIL IN1 0.69787f
C7 VIN IOUT 11.1689f
C8 LN1 REGFB 0.06934f
C9 LTAIL LN2 0.11377f
C10 ITAIL SENSE 5.59951f
C11 IN1 VSET 5.59773f
C12 LN1 VIN 10.9666f
C13 LCTRL VREG 5.601f
C14 VIN ICTRL 39.26f
C15 LTAIL REGFB 5.59502f
C16 VSET SENSE 1.71377f
C17 ITAIL VSET 5.60006f
C18 LTAIL VIN 22.6685f
C19 VIN IN2 11.0803f
C20 LTAIL LPB 1.32706f
C21 IN1 VIN 11.0109f
C22 ITAIL IPB 1.34064f
C23 LN2 LCTRL 1.11915f
C24 ICTRL IOUT 5.60766f
C25 VIN VREG 11.1245f
C26 VIN SENSE 15.138f
C27 LTAIL LN1 0.69787f
C28 ITAIL VIN 22.7341f
C29 VIN LCTRL 29.7513f
C30 VIN VSET 8.61431f
C31 REGFB LN2 5.60713f
C32 VIN LN2 11.0138f
C33 IN2 ICTRL 1.15199f
C34 VIN IPB 9.57555f
C35 SENSE ICTRL 5.60808f
C36 VIN REGFB 3.75099f
C37 VSET IOUT 0.00882f
C38 IN1 IN2 2.95002f
C39 LN1 VSET 5.5933f
C40 VREG VSS 20.53882f
C41 LCTRL VSS 25.45774f
C42 IOUT VSS 26.34561f
C43 SENSE VSS 14.42907f
C44 VIN VSS 1.76506p
C45 LN1 VSS 14.0397f
C46 LTAIL VSS 45.68222f
C47 ITAIL VSS 29.828f
.ends
