* NGSPICE file created from nrz_bias_power.ext - technology: gf180mcuD

.subckt nrz_bias_power VIN VSS VSET SENSE IOUT REGFB VREG IPB IN2 ICTRL LPB LN2 LCTRL
X0 VIN.t8 LPB.t2 LTAIL.t1 VIN.t7 pfet_06v0 ad=8.8p pd=40.88u as=8.8p ps=40.88u w=20u l=4u
X1 VIN.t1 LCTRL.t3 VREG.t0 VIN.t0 pfet_06v0 ad=44p pd=0.20088m as=44p ps=0.20088m w=100u l=10u
X2 VSS.t5 IN1.t3 IN2.t0 VSS.t4 nfet_06v0 ad=22p pd=0.10088m as=22p ps=0.10088m w=50u l=10u
X3 VSS.t7 IN1.t1 IN1.t2 VSS.t6 nfet_06v0 ad=22p pd=0.10088m as=22p ps=0.10088m w=50u l=10u
X4 VIN.t12 ICTRL.t3 IOUT.t0 VIN.t11 pfet_06v0 ad=44p pd=0.20088m as=44p ps=0.20088m w=100u l=10u
X5 VSS.t9 LN1.t3 LN2.t0 VSS.t8 nfet_06v0 ad=22p pd=0.10088m as=22p ps=0.10088m w=50u l=10u
X6 VIN.t14 ICTRL.t0 ICTRL.t1 VIN.t13 pfet_06v0 ad=44p pd=0.20088m as=44p ps=0.20088m w=100u l=10u
X7 VSS.t11 LN1.t1 LN1.t2 VSS.t10 nfet_06v0 ad=22p pd=0.10088m as=22p ps=0.10088m w=50u l=10u
X8 LTAIL.t2 VSET.t0 LN1.t0 VIN.t16 pfet_06v0 ad=44p pd=0.20088m as=44p ps=0.20088m w=100u l=10u
X9 VIN.t3 LCTRL.t0 LCTRL.t1 VIN.t2 pfet_06v0 ad=44p pd=0.20088m as=44p ps=0.20088m w=100u l=10u
X10 VIN.t6 LPB.t0 LPB.t1 VIN.t5 pfet_06v0 ad=8.8p pd=40.88u as=8.8p ps=40.88u w=20u l=4u
X11 ITAIL.t0 SENSE.t1 IN2.t1 VIN.t15 pfet_06v0 ad=44p pd=0.20088m as=44p ps=0.20088m w=100u l=10u
X12 VSS.t3 IN2.t2 ICTRL.t2 VSS.t2 nfet_06v0 ad=8.8p pd=40.88u as=8.8p ps=40.88u w=20u l=1u
X13 VIN.t19 IPB.t0 IPB.t1 VIN.t18 pfet_06v0 ad=8.8p pd=40.88u as=8.8p ps=40.88u w=20u l=4u
X14 LTAIL.t0 REGFB.t0 LN2.t1 VIN.t4 pfet_06v0 ad=44p pd=0.20088m as=44p ps=0.20088m w=100u l=10u
X15 VSS.t1 LN2.t2 LCTRL.t2 VSS.t0 nfet_06v0 ad=8.8p pd=40.88u as=8.8p ps=40.88u w=20u l=1u
X16 VIN.t10 ICTRL.t4 SENSE.t0 VIN.t9 pfet_06v0 ad=44p pd=0.20088m as=44p ps=0.20088m w=100u l=10u
X17 ITAIL.t1 VSET.t1 IN1.t0 VIN.t17 pfet_06v0 ad=44p pd=0.20088m as=44p ps=0.20088m w=100u l=10u
X18 VIN.t21 IPB.t2 ITAIL.t2 VIN.t20 pfet_06v0 ad=8.8p pd=40.88u as=8.8p ps=40.88u w=20u l=4u
R0 VREG VREG.t0 41.5805
R1 LCTRL.n0 LCTRL.t3 101.763
R2 LCTRL.n0 LCTRL.t0 96.8122
R3 LCTRL.n1 LCTRL.t1 38.6484
R4 LCTRL.n2 LCTRL.t2 29.364
R5 LCTRL.n2 LCTRL.n1 3.038
R6 LCTRL.n1 LCTRL.n0 1.184
R7 LCTRL LCTRL.n2 0.0905
R8 LN2.n0 LN2.t2 127.876
R9 LN2.n1 LN2.t1 39.1221
R10 LN2.n0 LN2.t0 33.2506
R11 LN2.n1 LN2.n0 9.9005
R12 LN2 LN2.n1 0.0905
R13 REGFB REGFB.t0 100.219
R14 LPB.n0 LPB.t2 65.7788
R15 LPB.n0 LPB.t0 61.7288
R16 LPB.n1 LPB.t1 30.2943
R17 LPB.n1 LPB.n0 0.509
R18 LPB LPB.n1 0.0905
R19 IOUT IOUT.t0 42.5279
R20 ICTRL.n0 ICTRL.t3 103.183
R21 ICTRL.n0 ICTRL.t4 98.2333
R22 ICTRL.n1 ICTRL.t0 98.2333
R23 ICTRL.n2 ICTRL.t1 40.0694
R24 ICTRL.n3 ICTRL.t2 30.785
R25 ICTRL.n1 ICTRL.n0 4.9505
R26 ICTRL.n3 ICTRL.n2 3.038
R27 ICTRL.n2 ICTRL.n1 1.184
R28 ICTRL ICTRL.n3 0.0905
R29 IN2.n0 IN2.t2 129.298
R30 IN2.n1 IN2.t1 40.5431
R31 IN2.n0 IN2.t0 34.6716
R32 IN2.n1 IN2.n0 9.9005
R33 IN2 IN2.n1 0.0905
R34 SENSE.n0 SENSE.t1 101.076
R35 SENSE.n0 SENSE.t0 65.578
R36 SENSE SENSE.n0 0.0905
R37 VSET.n0 VSET.t0 148.35
R38 VSET.n0 VSET.t1 101.549
R39 VSET VSET.n0 0.0905
R40 IPB.n0 IPB.t2 67.1998
R41 IPB.n0 IPB.t0 63.1498
R42 IPB.n1 IPB.t1 31.7153
R43 IPB.n1 IPB.n0 0.509
R44 IPB IPB.n1 0.0905
R45 VIN.n20 VIN.t18 131.619
R46 VIN.n18 VIN.t20 131.619
R47 VIN.n8 VIN.t5 131.619
R48 VIN.n6 VIN.t7 131.619
R49 VIN.n2 VIN.t2 99.7359
R50 VIN.n10 VIN.t11 99.7359
R51 VIN.n3 VIN.t4 99.7359
R52 VIN.n4 VIN.t16 99.7359
R53 VIN.n15 VIN.t15 99.7359
R54 VIN.n14 VIN.t13 99.7359
R55 VIN.n0 VIN.t0 99.7359
R56 VIN.n12 VIN.t9 99.7359
R57 VIN.n16 VIN.t17 99.7359
R58 VIN.n0 VIN.t1 47.2036
R59 VIN.n11 VIN.t10 44.3326
R60 VIN.n1 VIN.t3 44.3326
R61 VIN.n13 VIN.t14 44.3326
R62 VIN.n9 VIN.t12 44.3326
R63 VIN.n7 VIN.t6 35.0311
R64 VIN.n17 VIN.t21 35.0311
R65 VIN.n19 VIN.t19 35.0311
R66 VIN.n5 VIN.t8 35.0311
R67 VIN.n3 VIN.n2 18.9005
R68 VIN.n15 VIN.n14 18.9005
R69 VIN.n16 VIN.n15 4.9505
R70 VIN.n4 VIN.n3 4.9505
R71 VIN.n10 VIN.n9 2.8715
R72 VIN.n12 VIN.n11 2.8715
R73 VIN.n2 VIN.n1 2.8715
R74 VIN.n14 VIN.n13 2.8715
R75 VIN.n9 VIN.n8 2.7545
R76 VIN.n7 VIN.n6 2.5295
R77 VIN.n19 VIN.n18 2.5295
R78 VIN.n11 VIN.n10 2.0795
R79 VIN.n13 VIN.n12 2.0795
R80 VIN.n1 VIN.n0 2.0795
R81 VIN.n5 VIN.n4 1.8545
R82 VIN.n17 VIN.n16 1.8545
R83 VIN.n18 VIN.n17 1.5215
R84 VIN.n6 VIN.n5 1.5215
R85 VIN.n8 VIN.n7 1.5215
R86 VIN.n20 VIN.n19 1.5215
R87 VIN VIN.n20 0.0905
R88 VSS.n8 VSS.n2 6840.6
R89 VSS.n20 VSS.n7 621.611
R90 VSS.n34 VSS.n33 621.611
R91 VSS.n11 VSS.n10 621.444
R92 VSS.n11 VSS.n9 621.444
R93 VSS.n33 VSS.n1 621.444
R94 VSS.n35 VSS.n1 621.444
R95 VSS.n7 VSS.n6 621.444
R96 VSS.n17 VSS.n9 621.444
R97 VSS.n17 VSS.n10 621.444
R98 VSS.n30 VSS.n4 621.444
R99 VSS.n24 VSS.n4 621.444
R100 VSS.n24 VSS.n3 621.444
R101 VSS.n21 VSS.n6 621.444
R102 VSS.n30 VSS.n3 621.444
R103 VSS.n26 VSS.n25 458.818
R104 VSS.n13 VSS.n12 458.818
R105 VSS.n32 VSS.n31 316.796
R106 VSS.n19 VSS.n18 316.796
R107 VSS.t10 VSS.n19 188.69
R108 VSS.n12 VSS.t8 188.69
R109 VSS.n32 VSS.t6 188.69
R110 VSS.n25 VSS.t4 188.69
R111 VSS.n21 VSS.n20 144.732
R112 VSS.n35 VSS.n34 144.732
R113 VSS.n31 VSS.n2 125.584
R114 VSS.n18 VSS.n8 125.584
R115 VSS.t8 VSS.n8 63.1073
R116 VSS.t4 VSS.n2 63.1073
R117 VSS.n22 VSS.n21 38.3025
R118 VSS.n36 VSS.n35 38.3025
R119 VSS.n30 VSS.n29 38.3025
R120 VSS.n17 VSS.n16 38.3025
R121 VSS.n5 VSS.t11 37.9874
R122 VSS.n15 VSS.t9 37.9874
R123 VSS.n0 VSS.t7 37.9874
R124 VSS.n28 VSS.t5 37.9874
R125 VSS.n14 VSS.t1 35.533
R126 VSS.n23 VSS.n22 35.042
R127 VSS.n27 VSS.n26 35.0162
R128 VSS.n14 VSS.n13 35.0162
R129 VSS.n23 VSS.t3 34.5745
R130 VSS.n13 VSS.t0 33.7241
R131 VSS.n26 VSS.t2 33.7241
R132 VSS.n15 VSS.n14 2.9795
R133 VSS.n28 VSS.n27 2.9795
R134 VSS.n16 VSS.n15 2.8715
R135 VSS.n22 VSS.n5 2.8715
R136 VSS.n29 VSS.n28 2.8715
R137 VSS.n36 VSS.n0 2.8715
R138 VSS.n16 VSS.n5 2.0795
R139 VSS.n29 VSS.n0 2.0795
R140 VSS.n27 VSS.n23 0.959
R141 VSS.t4 VSS.n3 0.217167
R142 VSS.t10 VSS.n6 0.217167
R143 VSS.t4 VSS.n4 0.217167
R144 VSS.t6 VSS.n1 0.217167
R145 VSS.t8 VSS.n9 0.217167
R146 VSS.t8 VSS.n10 0.217167
R147 VSS VSS.n36 0.0905
R148 VSS.n20 VSS.t10 0.0514603
R149 VSS.n34 VSS.t6 0.0514603
R150 VSS.n12 VSS.n11 0.0477727
R151 VSS.n33 VSS.n32 0.0477727
R152 VSS.n18 VSS.n17 0.0477727
R153 VSS.n25 VSS.n24 0.0477727
R154 VSS.n19 VSS.n7 0.0477727
R155 VSS.n31 VSS.n30 0.0477727
R156 LN1.n0 LN1.t3 69.7754
R157 LN1.n0 LN1.t1 64.8254
R158 LN1.n2 LN1.t0 36.7536
R159 LN1.n1 LN1.t2 30.8822
R160 LN1.n2 LN1.n1 9.9005
R161 LN1.n1 LN1.n0 1.184
R162 LN1 LN1.n2 0.068
R163 LTAIL.n0 LTAIL.t0 42.1773
R164 LTAIL.n0 LTAIL.t2 37.2273
R165 LTAIL.n1 LTAIL.t1 27.9258
R166 LTAIL.n1 LTAIL.n0 5.7425
R167 LTAIL LTAIL.n1 0.068
R168 IN1.n0 IN1.t3 70.7228
R169 IN1.n0 IN1.t1 65.7728
R170 IN1.n2 IN1.t0 37.701
R171 IN1.n1 IN1.t2 31.8295
R172 IN1.n2 IN1.n1 9.9005
R173 IN1.n1 IN1.n0 1.184
R174 IN1 IN1.n2 0.068
R175 ITAIL.n0 ITAIL.t0 43.1247
R176 ITAIL.n0 ITAIL.t1 38.1747
R177 ITAIL.n1 ITAIL.t2 28.8732
R178 ITAIL.n1 ITAIL.n0 5.7425
R179 ITAIL ITAIL.n1 0.068
C0 IN1 VSET 5.59773f
C1 LN1 VIN 10.9666f
C2 LCTRL VREG 5.601f
C3 ITAIL IN2 0.06353f
C4 VIN ICTRL 39.26f
C5 LTAIL REGFB 5.59502f
C6 VSET SENSE 1.71377f
C7 ITAIL IN1 0.69787f
C8 LTAIL VIN 22.6685f
C9 ITAIL SENSE 5.59951f
C10 VIN IN2 11.0803f
C11 LTAIL LPB 1.32706f
C12 IN1 VIN 11.0109f
C13 LN2 LCTRL 1.11915f
C14 ICTRL IOUT 5.60766f
C15 VIN VREG 11.1245f
C16 ITAIL VSET 5.60006f
C17 VIN SENSE 15.138f
C18 LTAIL LN1 0.69787f
C19 VIN LCTRL 29.7513f
C20 ITAIL IPB 1.34064f
C21 VIN VSET 8.61431f
C22 REGFB LN2 5.60713f
C23 VIN LN2 11.0138f
C24 IN2 ICTRL 1.15199f
C25 ITAIL VIN 22.7341f
C26 VIN IPB 9.57555f
C27 SENSE ICTRL 5.60808f
C28 VIN REGFB 3.75099f
C29 VSET IOUT 0.00882f
C30 IN1 IN2 2.95002f
C31 LN1 VSET 5.5933f
C32 SENSE IN2 5.61384f
C33 VIN LPB 9.4247f
C34 LN1 LN2 2.94559f
C35 IN1 SENSE 0.06934f
C36 LTAIL VSET 5.59562f
C37 VIN IOUT 11.1689f
C38 LN1 REGFB 0.06934f
C39 LTAIL LN2 0.11377f
C40 VREG VSS 9.30893f
C41 LCTRL VSS 29.87246f
C42 LN2 VSS 25.68804f
C43 REGFB VSS 11.16076f
C44 LPB VSS 15.6763f
C45 IOUT VSS 9.56197f
C46 ICTRL VSS 41.12339f
C47 IN2 VSS 26.85734f
C48 SENSE VSS 19.48003f
C49 VSET VSS 28.08113f
C50 IPB VSS 16.56987f
C51 VIN VSS 1.69902p
C52 LN1 VSS 41.34693f
C53 LTAIL VSS 19.25991f
C54 IN1 VSS 42.26092f
C55 ITAIL VSS 20.10685f
C56 ITAIL.t0 VSS 24.24795f
C57 ITAIL.t1 VSS 17.96015f
C58 ITAIL.n0 VSS 7.13463f
C59 ITAIL.t2 VSS 5.22101f
C60 ITAIL.n1 VSS 2.60986f
C61 IN1.n0 VSS 2.2052f
C62 IN1.t2 VSS 4.52862f
C63 IN1.n1 VSS 0.4281f
C64 IN1.t0 VSS 8.18023f
C65 IN1.n2 VSS 0.48448f
C66 LTAIL.t0 VSS 18.10955f
C67 LTAIL.t2 VSS 18.4601f
C68 LTAIL.n0 VSS 7.05224f
C69 LTAIL.t1 VSS 5.17262f
C70 LTAIL.n1 VSS 2.55338f
C71 LN1.n0 VSS 2.19672f
C72 LN1.t2 VSS 4.51728f
C73 LN1.n1 VSS 0.41741f
C74 LN1.t0 VSS 8.60176f
C75 LN1.n2 VSS 0.47389f
C76 VSS.t7 VSS 3.74468f
C77 VSS.t11 VSS 3.74337f
C78 VSS.t1 VSS 0.95274f
C79 VSS.t9 VSS 3.78352f
C80 VSS.t3 VSS 0.95357f
C81 VSS.t5 VSS 3.78444f
C82 VIN.t1 VSS 8.78932f
C83 VIN.t0 VSS 17.9378f
C84 VIN.n0 VSS 4.68966f
C85 VIN.t3 VSS 8.70371f
C86 VIN.n1 VSS 0.48828f
C87 VIN.t2 VSS 17.9378f
C88 VIN.n2 VSS 4.47637f
C89 VIN.t4 VSS 17.9378f
C90 VIN.n3 VSS 4.50385f
C91 VIN.t16 VSS 17.9378f
C92 VIN.n4 VSS 4.27859f
C93 VIN.t8 VSS 2.13216f
C94 VIN.n5 VSS 0.35612f
C95 VIN.t7 VSS 1.96713f
C96 VIN.n6 VSS 1.43457f
C97 VIN.t6 VSS 2.09021f
C98 VIN.n7 VSS 0.36504f
C99 VIN.t5 VSS 1.96713f
C100 VIN.n8 VSS 1.43754f
C101 VIN.t12 VSS 8.50116f
C102 VIN.n9 VSS 0.4972f
C103 VIN.t11 VSS 17.9378f
C104 VIN.n10 VSS 4.25409f
C105 VIN.t10 VSS 8.44671f
C106 VIN.n11 VSS 0.48828f
C107 VIN.t9 VSS 17.9378f
C108 VIN.n12 VSS 4.25409f
C109 VIN.t14 VSS 8.44671f
C110 VIN.n13 VSS 0.48828f
C111 VIN.t13 VSS 17.9378f
C112 VIN.n14 VSS 4.47637f
C113 VIN.t15 VSS 17.9378f
C114 VIN.n15 VSS 4.50385f
C115 VIN.t17 VSS 17.9378f
C116 VIN.n16 VSS 4.27859f
C117 VIN.t21 VSS 2.13853f
C118 VIN.n17 VSS 0.35612f
C119 VIN.t20 VSS 1.96713f
C120 VIN.n18 VSS 1.43457f
C121 VIN.t19 VSS 2.09639f
C122 VIN.n19 VSS 0.36504f
C123 VIN.t18 VSS 1.96713f
C124 VIN.n20 VSS 1.40234f
C125 IPB.n0 VSS 2.72163f
C126 IPB.t1 VSS 2.68165f
C127 IPB.n1 VSS 0.65446f
C128 VSET.n0 VSS 4.59518f
C129 SENSE.t0 VSS 10.00644f
C130 SENSE.n0 VSS 5.34838f
C131 IN2.t0 VSS 7.76708f
C132 IN2.n0 VSS 5.63041f
C133 IN2.t1 VSS 19.51062f
C134 IN2.n1 VSS 2.52668f
C135 ICTRL.n0 VSS 4.49457f
C136 ICTRL.n1 VSS 2.28309f
C137 ICTRL.t1 VSS 8.40333f
C138 ICTRL.n2 VSS 0.4302f
C139 ICTRL.t2 VSS 1.41146f
C140 ICTRL.n3 VSS 0.30382f
C141 IOUT.t0 VSS 20.0915f
C142 LPB.n0 VSS 2.65009f
C143 LPB.t1 VSS 2.64307f
C144 LPB.n1 VSS 0.61905f
C145 LN2.t0 VSS 7.76708f
C146 LN2.n0 VSS 5.53896f
C147 LN2.t1 VSS 13.36134f
C148 LN2.n1 VSS 2.49601f
C149 LCTRL.n0 VSS 4.61561f
C150 LCTRL.t1 VSS 8.69628f
C151 LCTRL.n1 VSS 0.42931f
C152 LCTRL.t2 VSS 1.41082f
C153 LCTRL.n2 VSS 0.29797f
C154 VREG.t0 VSS 20.36335f
.ends
