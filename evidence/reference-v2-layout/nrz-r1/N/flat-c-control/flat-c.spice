* NGSPICE file created from nrz_bias_power.ext - technology: gf180mcuD

X0 VIN LPB LTAIL VIN pfet_06v0 ad=8.8p pd=40.88u as=8.8p ps=40.88u w=20u l=4u
X1 VIN LCTRL VREG VIN pfet_06v0 ad=44p pd=0.20088m as=44p ps=0.20088m w=100u l=10u
X2 VSS IN1 IN2 VSS nfet_06v0 ad=22p pd=0.10088m as=22p ps=0.10088m w=50u l=10u
X3 VSS IN1 IN1 VSS nfet_06v0 ad=22p pd=0.10088m as=22p ps=0.10088m w=50u l=10u
X4 VIN ICTRL IOUT VIN pfet_06v0 ad=44p pd=0.20088m as=44p ps=0.20088m w=100u l=10u
X5 VSS LN1 LN2 VSS nfet_06v0 ad=22p pd=0.10088m as=22p ps=0.10088m w=50u l=10u
X6 VIN ICTRL ICTRL VIN pfet_06v0 ad=44p pd=0.20088m as=44p ps=0.20088m w=100u l=10u
X7 VSS LN1 LN1 VSS nfet_06v0 ad=22p pd=0.10088m as=22p ps=0.10088m w=50u l=10u
X8 LTAIL VSET LN1 VIN pfet_06v0 ad=44p pd=0.20088m as=44p ps=0.20088m w=100u l=10u
X9 VIN LCTRL LCTRL VIN pfet_06v0 ad=44p pd=0.20088m as=44p ps=0.20088m w=100u l=10u
X10 VIN LPB LPB VIN pfet_06v0 ad=8.8p pd=40.88u as=8.8p ps=40.88u w=20u l=4u
X11 ITAIL SENSE IN2 VIN pfet_06v0 ad=44p pd=0.20088m as=44p ps=0.20088m w=100u l=10u
X12 VSS IN2 ICTRL VSS nfet_06v0 ad=8.8p pd=40.88u as=8.8p ps=40.88u w=20u l=1u
X13 VIN IPB IPB VIN pfet_06v0 ad=8.8p pd=40.88u as=8.8p ps=40.88u w=20u l=4u
X14 LTAIL REGFB LN2 VIN pfet_06v0 ad=44p pd=0.20088m as=44p ps=0.20088m w=100u l=10u
X15 VSS LN2 LCTRL VSS nfet_06v0 ad=8.8p pd=40.88u as=8.8p ps=40.88u w=20u l=1u
X16 VIN ICTRL SENSE VIN pfet_06v0 ad=44p pd=0.20088m as=44p ps=0.20088m w=100u l=10u
X17 ITAIL VSET IN1 VIN pfet_06v0 ad=44p pd=0.20088m as=44p ps=0.20088m w=100u l=10u
X18 VIN IPB ITAIL VIN pfet_06v0 ad=8.8p pd=40.88u as=8.8p ps=40.88u w=20u l=4u
C0 LTAIL LN1 0.69787f
C1 ITAIL VIN 22.7341f
C2 VIN LCTRL 29.7513f
C3 VIN VSET 8.61431f
C4 REGFB LN2 5.60713f
C5 VIN LN2 11.0138f
C6 IN2 ICTRL 1.15199f
C7 VIN IPB 9.57555f
C8 SENSE ICTRL 5.60808f
C9 VIN REGFB 3.75099f
C10 VSET IOUT 0.00882f
C11 IN1 IN2 2.95002f
C12 LN1 VSET 5.5933f
C13 SENSE IN2 5.61384f
C14 VIN LPB 9.4247f
C15 LN1 LN2 2.94559f
C16 IN1 SENSE 0.06934f
C17 LTAIL VSET 5.59562f
C18 ITAIL IN2 0.06353f
C19 ITAIL IN1 0.69787f
C20 VIN IOUT 11.1689f
C21 LN1 REGFB 0.06934f
C22 LTAIL LN2 0.11377f
C23 ITAIL SENSE 5.59951f
C24 IN1 VSET 5.59773f
C25 LN1 VIN 10.9666f
C26 LCTRL VREG 5.601f
C27 VIN ICTRL 39.26f
C28 LTAIL REGFB 5.59502f
C29 VSET SENSE 1.71377f
C30 ITAIL VSET 5.60006f
C31 LTAIL VIN 22.6685f
C32 VIN IN2 11.0803f
C33 LTAIL LPB 1.32706f
C34 IN1 VIN 11.0109f
C35 ITAIL IPB 1.34064f
C36 LN2 LCTRL 1.11915f
C37 ICTRL IOUT 5.60766f
C38 VIN VREG 11.1245f
C39 VIN SENSE 15.138f
C40 VREG VSS 5.60352f
C41 LCTRL VSS 29.8706f
C42 LN2 VSS 25.679f
C43 REGFB VSS 9.12814f
C44 LPB VSS 15.6721f
C45 IOUT VSS 5.78481f
C46 ICTRL VSS 41.1216f
C47 IN2 VSS 26.8485f
C48 SENSE VSS 19.4768f
C49 VSET VSS 28.0794f
C50 IPB VSS 16.5657f
C51 VIN VSS 1.69902p
C52 LN1 VSS 41.3448f ; **FLOATING
C53 LTAIL VSS 19.2424f ; **FLOATING
C54 IN1 VSS 42.2588f ; **FLOATING
C55 ITAIL VSS 20.0896f ; **FLOATING
