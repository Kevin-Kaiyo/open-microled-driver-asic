* C-placement sensitivity control: same full R/MOS, all .ext C at original nets.
.subckt nrz_bias_power VIN VSS VSET SENSE IOUT REGFB VREG IPB IN2 ICTRL LPB LN2 LCTRL
X0 VIN.t8 LPB.t2 LTAIL.t1 VIN.t7 pfet_06v0 ad=8.8p pd=40.88u as=8.8p ps=40.88u w=20u l=4u
X1 VIN.t1 LCTRL.t3 VREG.t0 VIN.t0 pfet_06v0 ad=44p pd=0.20088m as=44p ps=0.20088m w=100u l=10u
X2 VSS.t7 IN1.t3 IN2.t0 VSS.t6 nfet_06v0 ad=22p pd=0.10088m as=22p ps=0.10088m w=50u l=10u
X3 VSS.t5 IN1.t1 IN1.t2 VSS.t4 nfet_06v0 ad=22p pd=0.10088m as=22p ps=0.10088m w=50u l=10u
X4 VIN.t12 ICTRL.t3 IOUT.t0 VIN.t11 pfet_06v0 ad=44p pd=0.20088m as=44p ps=0.20088m w=100u l=10u
X5 VSS.t11 LN1.t3 LN2.t0 VSS.t10 nfet_06v0 ad=22p pd=0.10088m as=22p ps=0.10088m w=50u l=10u
X6 VIN.t14 ICTRL.t0 ICTRL.t1 VIN.t13 pfet_06v0 ad=44p pd=0.20088m as=44p ps=0.20088m w=100u l=10u
X7 VSS.t9 LN1.t1 LN1.t2 VSS.t8 nfet_06v0 ad=22p pd=0.10088m as=22p ps=0.10088m w=50u l=10u
X8 LTAIL.t2 VSET.t0 LN1.t0 VIN.t16 pfet_06v0 ad=44p pd=0.20088m as=44p ps=0.20088m w=100u l=10u
X9 VIN.t3 LCTRL.t0 LCTRL.t1 VIN.t2 pfet_06v0 ad=44p pd=0.20088m as=44p ps=0.20088m w=100u l=10u
X10 VIN.t6 LPB.t0 LPB.t1 VIN.t5 pfet_06v0 ad=8.8p pd=40.88u as=8.8p ps=40.88u w=20u l=4u
X11 ITAIL.t0 SENSE.t1 IN2.t1 VIN.t15 pfet_06v0 ad=44p pd=0.20088m as=44p ps=0.20088m w=100u l=10u
X12 VSS.t3 IN2.t2 ICTRL.t2 VSS.t2 nfet_06v0 ad=8.8p pd=40.88u as=8.8p ps=40.88u w=20u l=1u
X13 VIN.t19 IPB.t0 IPB.t1 VIN.t18 pfet_06v0 ad=8.8p pd=40.88u as=8.8p ps=40.88u w=20u l=4u
X14 LTAIL.t0 REGFB.t0 LN2.t1 VIN.t4 pfet_06v0 ad=44p pd=0.20088m as=44p ps=0.20088m w=100u l=10u
X15 VSS.t1 LN2.t2 LCTRL.t2 VSS.t0 nfet_06v0 ad=8.8p pd=40.88u as=8.8p ps=40.88u w=20u l=1u
X16 VIN.t10 ICTRL.t4 SENSE.t0 VIN.t9 pfet_06v0 ad=44p pd=0.20088m as=44p ps=0.20088m w=100u l=10u
X17 ITAIL.t1 VSET.t1 IN1.t0 VIN.t17 pfet_06v0 ad=44p pd=0.20088m as=44p ps=0.20088m w=100u l=10u
X18 VIN.t21 IPB.t2 ITAIL.t2 VIN.t20 pfet_06v0 ad=8.8p pd=40.88u as=8.8p ps=40.88u w=20u l=4u
R0 VREG VREG.t0 41.5805
R1 LCTRL.n0 LCTRL.t3 101.763
R2 LCTRL.n0 LCTRL.t0 96.8122
R3 LCTRL.n1 LCTRL.t1 38.6484
R4 LCTRL.n2 LCTRL.t2 29.364
R5 LCTRL.n2 LCTRL.n1 3.038
R6 LCTRL.n1 LCTRL.n0 1.184
R7 LCTRL LCTRL.n2 0.0905
R8 LN2.n0 LN2.t2 127.876
R9 LN2.n1 LN2.t1 39.1221
R10 LN2.n0 LN2.t0 33.2506
R11 LN2.n1 LN2.n0 9.9005
R12 LN2 LN2.n1 0.0905
R13 REGFB REGFB.t0 100.219
R14 LPB.n0 LPB.t2 65.7788
R15 LPB.n0 LPB.t0 61.7288
R16 LPB.n1 LPB.t1 30.2943
R17 LPB.n1 LPB.n0 0.509
R18 LPB LPB.n1 0.0905
R19 IOUT IOUT.t0 42.5279
R20 ICTRL.n0 ICTRL.t3 103.183
R21 ICTRL.n0 ICTRL.t4 98.2333
R22 ICTRL.n1 ICTRL.t0 98.2333
R23 ICTRL.n2 ICTRL.t1 40.0694
R24 ICTRL.n3 ICTRL.t2 30.785
R25 ICTRL.n1 ICTRL.n0 4.9505
R26 ICTRL.n3 ICTRL.n2 3.038
R27 ICTRL.n2 ICTRL.n1 1.184
R28 ICTRL ICTRL.n3 0.0905
R29 IN2.n0 IN2.t2 129.298
R30 IN2.n1 IN2.t1 40.5431
R31 IN2.n0 IN2.t0 34.6716
R32 IN2.n1 IN2.n0 9.9005
R33 IN2 IN2.n1 0.0905
R34 SENSE.n0 SENSE.t1 101.076
R35 SENSE.n0 SENSE.t0 65.578
R36 SENSE SENSE.n0 0.0905
R37 VSET.n0 VSET.t0 148.35
R38 VSET.n0 VSET.t1 101.549
R39 VSET VSET.n0 0.0905
R40 IPB.n0 IPB.t2 67.1998
R41 IPB.n0 IPB.t0 63.1498
R42 IPB.n1 IPB.t1 31.7153
R43 IPB.n1 IPB.n0 0.509
R44 IPB IPB.n1 0.0905
R45 VIN.n20 VIN.t18 131.619
R46 VIN.n18 VIN.t20 131.619
R47 VIN.n8 VIN.t5 131.619
R48 VIN.n6 VIN.t7 131.619
R49 VIN.n2 VIN.t2 99.7359
R50 VIN.n10 VIN.t11 99.7359
R51 VIN.n3 VIN.t4 99.7359
R52 VIN.n4 VIN.t16 99.7359
R53 VIN.n15 VIN.t15 99.7359
R54 VIN.n14 VIN.t13 99.7359
R55 VIN.n0 VIN.t0 99.7359
R56 VIN.n12 VIN.t9 99.7359
R57 VIN.n16 VIN.t17 99.7359
R58 VIN.n0 VIN.t1 47.2036
R59 VIN.n11 VIN.t10 44.3326
R60 VIN.n1 VIN.t3 44.3326
R61 VIN.n13 VIN.t14 44.3326
R62 VIN.n9 VIN.t12 44.3326
R63 VIN.n7 VIN.t6 35.0311
R64 VIN.n17 VIN.t21 35.0311
R65 VIN.n19 VIN.t19 35.0311
R66 VIN.n5 VIN.t8 35.0311
R67 VIN.n3 VIN.n2 18.9005
R68 VIN.n15 VIN.n14 18.9005
R69 VIN.n16 VIN.n15 4.9505
R70 VIN.n4 VIN.n3 4.9505
R71 VIN.n10 VIN.n9 2.8715
R72 VIN.n12 VIN.n11 2.8715
R73 VIN.n2 VIN.n1 2.8715
R74 VIN.n14 VIN.n13 2.8715
R75 VIN.n9 VIN.n8 2.7545
R76 VIN.n7 VIN.n6 2.5295
R77 VIN.n19 VIN.n18 2.5295
R78 VIN.n11 VIN.n10 2.0795
R79 VIN.n13 VIN.n12 2.0795
R80 VIN.n1 VIN.n0 2.0795
R81 VIN.n5 VIN.n4 1.8545
R82 VIN.n17 VIN.n16 1.8545
R83 VIN.n18 VIN.n17 1.5215
R84 VIN.n6 VIN.n5 1.5215
R85 VIN.n8 VIN.n7 1.5215
R86 VIN.n20 VIN.n19 1.5215
R87 VIN VIN.n20 0.0905
R88 VSS.n8 VSS.n2 6840.6
R89 VSS.n20 VSS.n7 621.611
R90 VSS.n34 VSS.n33 621.611
R91 VSS.n11 VSS.n10 621.444
R92 VSS.n11 VSS.n9 621.444
R93 VSS.n33 VSS.n1 621.444
R94 VSS.n35 VSS.n1 621.444
R95 VSS.n7 VSS.n6 621.444
R96 VSS.n17 VSS.n9 621.444
R97 VSS.n17 VSS.n10 621.444
R98 VSS.n30 VSS.n4 621.444
R99 VSS.n24 VSS.n4 621.444
R100 VSS.n24 VSS.n3 621.444
R101 VSS.n21 VSS.n6 621.444
R102 VSS.n30 VSS.n3 621.444
R103 VSS.n26 VSS.n25 458.818
R104 VSS.n13 VSS.n12 458.818
R105 VSS.n32 VSS.n31 316.796
R106 VSS.n19 VSS.n18 316.796
R107 VSS.t8 VSS.n19 188.69
R108 VSS.n12 VSS.t10 188.69
R109 VSS.n32 VSS.t4 188.69
R110 VSS.n25 VSS.t6 188.69
R111 VSS.n21 VSS.n20 144.732
R112 VSS.n35 VSS.n34 144.732
R113 VSS.n31 VSS.n2 125.584
R114 VSS.n18 VSS.n8 125.584
R115 VSS.t10 VSS.n8 63.1073
R116 VSS.t6 VSS.n2 63.1073
R117 VSS.n22 VSS.n21 38.3025
R118 VSS.n36 VSS.n35 38.3025
R119 VSS.n30 VSS.n29 38.3025
R120 VSS.n17 VSS.n16 38.3025
R121 VSS.n5 VSS.t9 37.9874
R122 VSS.n15 VSS.t11 37.9874
R123 VSS.n0 VSS.t5 37.9874
R124 VSS.n28 VSS.t7 37.9874
R125 VSS.n14 VSS.t1 35.533
R126 VSS.n23 VSS.n22 35.042
R127 VSS.n27 VSS.n26 35.0162
R128 VSS.n14 VSS.n13 35.0162
R129 VSS.n23 VSS.t3 34.5745
R130 VSS.n13 VSS.t0 33.7241
R131 VSS.n26 VSS.t2 33.7241
R132 VSS.n15 VSS.n14 2.9795
R133 VSS.n28 VSS.n27 2.9795
R134 VSS.n16 VSS.n15 2.8715
R135 VSS.n22 VSS.n5 2.8715
R136 VSS.n29 VSS.n28 2.8715
R137 VSS.n36 VSS.n0 2.8715
R138 VSS.n16 VSS.n5 2.0795
R139 VSS.n29 VSS.n0 2.0795
R140 VSS.n27 VSS.n23 0.959
R141 VSS.t6 VSS.n3 0.217167
R142 VSS.t8 VSS.n6 0.217167
R143 VSS.t6 VSS.n4 0.217167
R144 VSS.t4 VSS.n1 0.217167
R145 VSS.t10 VSS.n9 0.217167
R146 VSS.t10 VSS.n10 0.217167
R147 VSS VSS.n36 0.0905
R148 VSS.n20 VSS.t8 0.0514603
R149 VSS.n34 VSS.t4 0.0514603
R150 VSS.n12 VSS.n11 0.0477727
R151 VSS.n33 VSS.n32 0.0477727
R152 VSS.n18 VSS.n17 0.0477727
R153 VSS.n25 VSS.n24 0.0477727
R154 VSS.n19 VSS.n7 0.0477727
R155 VSS.n31 VSS.n30 0.0477727
R156 LN1.n0 LN1.t3 69.7754
R157 LN1.n0 LN1.t1 64.8254
R158 LN1.n4 LN1.n3 36.7354
R159 LN1.n1 LN1.t2 30.8822
R160 LN1.n4 LN1.n1 9.9005
R161 LN1.n1 LN1.n0 1.184
R162 LN1 LN1.n4 0.068
R163 LN1.n3 LN1.t0 0.0187
R164 LN1.n3 LN1.n2 0.0131
R165 LTAIL.n0 LTAIL.t0 42.1773
R166 LTAIL.n0 LTAIL.t2 37.2273
R167 LTAIL.n3 LTAIL.n2 27.8348
R168 LTAIL.n3 LTAIL.n0 5.7425
R169 LTAIL.n2 LTAIL.t1 0.0915
R170 LTAIL LTAIL.n3 0.068
R171 LTAIL.n2 LTAIL.n1 0.0635
R172 IN1.n0 IN1.t3 70.7228
R173 IN1.n0 IN1.t1 65.7728
R174 IN1.n4 IN1.n3 37.6828
R175 IN1.n1 IN1.t2 31.8295
R176 IN1.n4 IN1.n1 9.9005
R177 IN1.n1 IN1.n0 1.184
R178 IN1 IN1.n4 0.068
R179 IN1.n3 IN1.t0 0.0187
R180 IN1.n3 IN1.n2 0.0131
R181 ITAIL.n0 ITAIL.t0 43.1247
R182 ITAIL.n0 ITAIL.t1 38.1747
R183 ITAIL.n3 ITAIL.n2 28.7822
R184 ITAIL.n3 ITAIL.n0 5.7425
R185 ITAIL.n2 ITAIL.t2 0.0915
R186 ITAIL ITAIL.n3 0.068
R187 ITAIL.n2 ITAIL.n1 0.0635
C0 ICTRL VSS 4.1121600000000001e-14
C1 IN1 VSS 4.2258800000000009e-14
C2 IN2 VSS 2.6848500000000002e-14
C3 IOUT VSS 5.784810000000001e-15
C4 IPB VSS 1.6565700000000003e-14
C5 ITAIL VSS 2.0089599999999999e-14
C6 LCTRL VSS 2.9870600000000002e-14
C7 LN1 VSS 4.1344800000000004e-14
C8 LN2 VSS 2.5679000000000001e-14
C9 LPB VSS 1.5672100000000002e-14
C10 LTAIL VSS 1.9242400000000002e-14
C11 REGFB VSS 9.1281400000000001e-15
C12 SENSE VSS 1.9476800000000001e-14
C13 VIN VSS 1.6990200000000002e-12
C14 VREG VSS 5.6035200000000008e-15
C15 VSET VSS 2.8079400000000003e-14
C16 IN1 SENSE 6.9340500000000005e-17
C17 REGFB LN2 5.6071300000000008e-15
C18 VIN IN1 1.1010900000000001e-14
C19 ICTRL SENSE 5.6080800000000002e-15
C20 REGFB VIN 3.7509899999999998e-15
C21 ICTRL IOUT 5.6076600000000001e-15
C22 ICTRL VIN 3.9260000000000001e-14
C23 IN1 IN2 2.9500200000000002e-15
C24 LTAIL LN1 6.9786699999999999e-16
C25 LN2 VIN 1.1013800000000001e-14
C26 LTAIL VSET 5.59562e-15
C27 ICTRL IN2 1.15199e-15
C28 ITAIL VSET 5.6000600000000005e-15
C29 VIN SENSE 1.5138000000000003e-14
C30 IOUT VIN 1.1168900000000001e-14
C31 LN2 LCTRL 1.1191500000000002e-15
C32 SENSE IN2 5.6138400000000005e-15
C33 LTAIL REGFB 5.5950200000000007e-15
C34 ITAIL IN1 6.9786699999999999e-16
C35 VIN IN2 1.10803e-14
C36 LN1 VSET 5.5933000000000004e-15
C37 LCTRL VIN 2.9751299999999999e-14
C38 LPB VIN 9.4247000000000019e-15
C39 VIN IPB 9.57555e-15
C40 LN1 REGFB 6.9340500000000005e-17
C41 LTAIL LN2 1.13766e-16
C42 VREG VIN 1.11245e-14
C43 ITAIL SENSE 5.5995100000000009e-15
C44 VSET IN1 5.5977300000000003e-15
C45 LTAIL VIN 2.2668500000000001e-14
C46 VIN ITAIL 2.2734100000000002e-14
C47 LCTRL VREG 5.6010000000000001e-15
C48 LN1 LN2 2.9455900000000002e-15
C49 VSET SENSE 1.71377e-15
C50 ITAIL IN2 6.3526200000000013e-17
C51 IOUT VSET 8.8164600000000003e-18
C52 LN1 VIN 1.0966600000000001e-14
C53 LPB LTAIL 1.3270600000000001e-15
C54 IPB ITAIL 1.3406400000000002e-15
C55 VIN VSET 8.6143099999999994e-15
.ends nrz_bias_power
