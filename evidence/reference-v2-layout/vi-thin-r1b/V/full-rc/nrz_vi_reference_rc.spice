* Audited RC model assembly from build/reference-v2-layout/vi-thin-r1b/V/readback/nrz_vi_reference.ext.
* Original Magic RC preserved in ../unmodified-full-rc/.
* R/MOS unchanged; C counted once with post-simplification allocation weights.
* Coupling remains at original logical nodes; no EM claim.
.subckt nrz_vi_reference VIN VSS VSET SENSE IOUT IPB IN2 ICTRL
X0 VSS.t5 IN1.t3 IN2.t0 VSS.t4 nfet_06v0 ad=22p pd=0.10088m as=22p ps=0.10088m w=50u l=10u
X1 VSS.t3 IN1.t1 IN1.t2 VSS.t2 nfet_06v0 ad=22p pd=0.10088m as=22p ps=0.10088m w=50u l=10u
X2 VIN.t1 ICTRL.t3 IOUT.t0 VIN.t0 pfet_06v0 ad=44p pd=0.20088m as=44p ps=0.20088m w=100u l=10u
X3 VIN.t3 ICTRL.t0 ICTRL.t1 VIN.t2 pfet_06v0 ad=44p pd=0.20088m as=44p ps=0.20088m w=100u l=10u
X4 ITAIL.t0 SENSE.t1 IN2.t1 VIN.t6 pfet_06v0 ad=44p pd=0.20088m as=44p ps=0.20088m w=100u l=10u
X5 VSS.t1 IN2.t2 ICTRL.t2 VSS.t0 nfet_06v0 ad=8.8p pd=40.88u as=8.8p ps=40.88u w=20u l=1u
X6 VIN.t11 IPB.t0 IPB.t1 VIN.t10 pfet_06v0 ad=8.8p pd=40.88u as=8.8p ps=40.88u w=20u l=4u
X7 VIN.t5 ICTRL.t4 SENSE.t0 VIN.t4 pfet_06v0 ad=44p pd=0.20088m as=44p ps=0.20088m w=100u l=10u
X8 ITAIL.t1 VSET.t0 IN1.t0 VIN.t7 pfet_06v0 ad=44p pd=0.20088m as=44p ps=0.20088m w=100u l=10u
X9 VIN.t9 IPB.t2 ITAIL.t2 VIN.t8 pfet_06v0 ad=8.8p pd=40.88u as=8.8p ps=40.88u w=20u l=4u
R0 IOUT IOUT.t0 42.5279
R1 ICTRL.n0 ICTRL.t3 104.13
R2 ICTRL.n0 ICTRL.t4 99.1807
R3 ICTRL.n1 ICTRL.t0 99.1807
R4 ICTRL.n2 ICTRL.t1 41.0168
R5 ICTRL.n3 ICTRL.t2 31.7324
R6 ICTRL.n1 ICTRL.n0 4.9505
R7 ICTRL.n3 ICTRL.n2 3.038
R8 ICTRL.n2 ICTRL.n1 1.184
R9 ICTRL ICTRL.n3 0.0905
R10 IN2.n0 IN2.t2 130.244
R11 IN2.n1 IN2.t1 41.4905
R12 IN2.n0 IN2.t0 35.619
R13 IN2.n1 IN2.n0 9.9005
R14 IN2 IN2.n1 0.0905
R15 SENSE.n0 SENSE.t1 101.076
R16 SENSE.n0 SENSE.t0 65.578
R17 SENSE SENSE.n0 0.0905
R18 VSET VSET.t0 101.639
R19 IPB.n0 IPB.t2 68.1472
R20 IPB.n0 IPB.t0 64.0972
R21 IPB.n1 IPB.t1 32.6627
R22 IPB.n1 IPB.n0 0.509
R23 IPB IPB.n1 0.0905
R24 VIN.n10 VIN.t10 131.619
R25 VIN.n8 VIN.t8 131.619
R26 VIN.n5 VIN.t6 99.7359
R27 VIN.n4 VIN.t2 99.7359
R28 VIN.n2 VIN.t4 99.7359
R29 VIN.n0 VIN.t0 99.7359
R30 VIN.n6 VIN.t7 99.7359
R31 VIN.n0 VIN.t1 47.2036
R32 VIN.n3 VIN.t3 44.3326
R33 VIN.n1 VIN.t5 44.3326
R34 VIN.n9 VIN.t11 35.0311
R35 VIN.n7 VIN.t9 35.0311
R36 VIN.n5 VIN.n4 18.9005
R37 VIN.n6 VIN.n5 4.9505
R38 VIN.n2 VIN.n1 2.8715
R39 VIN.n4 VIN.n3 2.8715
R40 VIN.n9 VIN.n8 2.5295
R41 VIN.n1 VIN.n0 2.0795
R42 VIN.n3 VIN.n2 2.0795
R43 VIN.n7 VIN.n6 1.8545
R44 VIN.n8 VIN.n7 1.5215
R45 VIN.n10 VIN.n9 1.5215
R46 VIN VIN.n10 0.0905
R47 VSS.n14 VSS.n13 621.611
R48 VSS.n4 VSS.n2 621.444
R49 VSS.n13 VSS.n1 621.444
R50 VSS.n15 VSS.n1 621.444
R51 VSS.n4 VSS.n3 621.444
R52 VSS.n10 VSS.n2 621.444
R53 VSS.n10 VSS.n3 621.444
R54 VSS.n6 VSS.n5 458.818
R55 VSS.n12 VSS.n11 316.796
R56 VSS.n12 VSS.t2 188.69
R57 VSS.n5 VSS.t4 188.69
R58 VSS.n11 VSS.t4 188.69
R59 VSS.n15 VSS.n14 144.732
R60 VSS.n16 VSS.n15 38.3025
R61 VSS.n10 VSS.n9 38.3025
R62 VSS.n8 VSS.t5 37.9874
R63 VSS.n0 VSS.t3 37.9874
R64 VSS.n7 VSS.t1 35.533
R65 VSS.n7 VSS.n6 35.0162
R66 VSS.n6 VSS.t0 33.7241
R67 VSS.n8 VSS.n7 2.9795
R68 VSS.n9 VSS.n8 2.8715
R69 VSS.n16 VSS.n0 2.8715
R70 VSS.n9 VSS.n0 2.0795
R71 VSS.n2 VSS.t4 0.217167
R72 VSS.n3 VSS.t4 0.217167
R73 VSS.t2 VSS.n1 0.217167
R74 VSS VSS.n16 0.0905
R75 VSS.n14 VSS.t2 0.0514603
R76 VSS.n11 VSS.n10 0.0477727
R77 VSS.n13 VSS.n12 0.0477727
R78 VSS.n5 VSS.n4 0.0477727
R79 IN1.n0 IN1.t3 73.0912
R80 IN1.n0 IN1.t1 68.1412
R81 IN1.n4 IN1.n3 40.0512
R82 IN1.n1 IN1.t2 34.198
R83 IN1.n4 IN1.n1 9.9005
R84 IN1.n1 IN1.n0 1.184
R85 IN1 IN1.n4 0.068
R86 IN1.n3 IN1.t0 0.0187
R87 IN1.n3 IN1.n2 0.0131
R88 ITAIL.n0 ITAIL.t0 45.4931
R89 ITAIL.n0 ITAIL.t1 40.5431
R90 ITAIL.n3 ITAIL.n2 31.1506
R91 ITAIL.n3 ITAIL.n0 5.7425
R92 ITAIL.n2 ITAIL.t2 0.0915
R93 ITAIL ITAIL.n3 0.068
R94 ITAIL.n2 ITAIL.n1 0.0635
C0 ICTRL VSS 1.4498453489195185e-18
C1 ICTRL.n0 VSS 3.6344846289071285e-15
C2 ICTRL.n1 VSS 1.8457919716837877e-15
C3 ICTRL.n2 VSS 3.5688724136884956e-16
C4 ICTRL.n3 VSS 2.5474613675100359e-16
C5 ICTRL.t0 VSS 1.1380200513556959e-14
C6 ICTRL.t1 VSS 1.1201316737208335e-15
C7 ICTRL.t2 VSS 3.7928197461339595e-16
C8 ICTRL.t3 VSS 1.1467425500492163e-14
C9 ICTRL.t4 VSS 1.1380200513556959e-14
C10 IN1 VSS 4.5395836051352519e-18
C11 IN1.n0 VSS 4.7919269161566203e-15
C12 IN1.n1 VSS 9.7810854833678884e-16
C13 IN1.n2 VSS 2.918300706353634e-16
C14 IN1.n3 VSS 2.2693236726374066e-15
C15 IN1.n4 VSS 1.0976561653348715e-15
C16 IN1.t0 VSS 4.2153397925588436e-16
C17 IN1.t1 VSS 1.6124246037838777e-14
C18 IN1.t2 VSS 1.7400942750712638e-15
C19 IN1.t3 VSS 1.6291240751127896e-14
C20 IN2 VSS 1.0798165242819098e-17
C21 IN2.n0 VSS 7.0452926615167674e-15
C22 IN2.n1 VSS 3.1536280263776768e-15
C23 IN2.t0 VSS 4.9316247677335105e-15
C24 IN2.t1 VSS 8.3767280616949831e-15
C25 IN2.t2 VSS 2.3638283174342491e-15
C26 IOUT VSS 1.300453834375687e-15
C27 IOUT.t0 VSS 4.4786361656243144e-15
C28 IPB VSS 6.4446852587401343e-18
C29 IPB.n0 VSS 4.2965908454098563e-15
C30 IPB.n1 VSS 1.0518928811267577e-15
C31 IPB.t0 VSS 4.9479849173535518e-15
C32 IPB.t1 VSS 1.7273199431488356e-15
C33 IPB.t2 VSS 5.0791667277022595e-15
C34 ITAIL VSS 9.9718946180993451e-18
C35 ITAIL.n0 VSS 4.3914022690385781e-15
C36 ITAIL.n1 VSS 1.2820981866756485e-16
C37 ITAIL.n2 VSS 1.9021799970140618e-15
C38 ITAIL.n3 VSS 1.6378994135101407e-15
C39 ITAIL.t0 VSS 6.8090121068460381e-15
C40 ITAIL.t1 VSS 6.5764323416794792e-15
C41 ITAIL.t2 VSS 1.8519215862603669e-16
C42 SENSE VSS 1.8585571555287936e-18
C43 SENSE.n0 VSS 3.0797105007098873e-15
C44 SENSE.t0 VSS 1.7145611122220815e-15
C45 SENSE.t1 VSS 1.4633569829912508e-14
C46 VIN VSS 1.3289445362002495e-17
C47 VIN.n0 VSS 3.4934621413223237e-14
C48 VIN.n1 VSS 3.6373618393505924e-15
C49 VIN.n10 VSS 1.0446411359422052e-14
C50 VIN.n2 VSS 3.1689886215990214e-14
C51 VIN.n3 VSS 3.6373618393505924e-15
C52 VIN.n4 VSS 3.3345785301190116e-14
C53 VIN.n5 VSS 3.3550432625136274e-14
C54 VIN.n6 VSS 3.187242982456526e-14
C55 VIN.n7 VSS 2.6528217580603189e-15
C56 VIN.n8 VSS 1.0686469737585198e-14
C57 VIN.n9 VSS 2.7192757513138126e-15
C58 VIN.t0 VSS 1.3362372586186103e-13
C59 VIN.t1 VSS 1.077217802167727e-14
C60 VIN.t10 VSS 1.4653710733173318e-14
C61 VIN.t11 VSS 3.7722696858197276e-15
C62 VIN.t2 VSS 1.3362372586186103e-13
C63 VIN.t3 VSS 1.0562042360241006e-14
C64 VIN.t4 VSS 1.3362372586186103e-13
C65 VIN.t5 VSS 1.0562042360241006e-14
C66 VIN.t6 VSS 1.3362372586186103e-13
C67 VIN.t7 VSS 1.3362372586186103e-13
C68 VIN.t8 VSS 1.4653710733173318e-14
C69 VIN.t9 VSS 3.7722696858197276e-15
C70 VSET VSS 1.2794492361493503e-15
C71 VSET.t0 VSS 8.1896607638506515e-15
C72 IN1 SENSE 6.9340500000000005e-17
C73 VIN IN1 1.1121600000000001e-14
C74 IN1 IN2 3.1853200000000003e-15
C75 ITAIL VSET 5.6111499999999997e-15
C76 VIN SENSE 1.5429700000000001e-14
C77 SENSE IN2 6.0049600000000005e-15
C78 ITAIL IN1 6.9786699999999999e-16
C79 VIN IN2 1.1124600000000001e-14
C80 ICTRL SENSE 5.7641700000000007e-15
C81 VIN IPB 9.6721299999999997e-15
C82 ICTRL VIN 3.9321800000000007e-14
C83 ITAIL SENSE 5.6093800000000004e-15
C84 VSET IN1 5.6088200000000003e-15
C85 ICTRL IN2 1.1738900000000002e-15
C86 VIN ITAIL 2.28981e-14
C87 IOUT VIN 1.1173200000000001e-14
C88 ITAIL IN2 1.61524e-16
C89 IPB ITAIL 1.3931300000000002e-15
C90 VIN VSET 3.7625800000000005e-15
C91 ICTRL IOUT 5.6173600000000002e-15
.ends nrz_vi_reference
