* NGSPICE file created from nrz_vi_reference.ext - technology: gf180mcuD

.subckt nrz_vi_reference VIN VSS VSET SENSE IOUT IPB IN2 ICTRL
X0 VSS.t5 IN1.t3 IN2.t0 VSS.t4 nfet_06v0 ad=22p pd=0.10088m as=22p ps=0.10088m w=50u l=10u
X1 VSS.t3 IN1.t1 IN1.t2 VSS.t2 nfet_06v0 ad=22p pd=0.10088m as=22p ps=0.10088m w=50u l=10u
X2 VIN.t1 ICTRL.t3 IOUT.t0 VIN.t0 pfet_06v0 ad=44p pd=0.20088m as=44p ps=0.20088m w=100u l=10u
X3 VIN.t3 ICTRL.t0 ICTRL.t1 VIN.t2 pfet_06v0 ad=44p pd=0.20088m as=44p ps=0.20088m w=100u l=10u
X4 ITAIL.t0 SENSE.t1 IN2.t1 VIN.t6 pfet_06v0 ad=44p pd=0.20088m as=44p ps=0.20088m w=100u l=10u
X5 VSS.t1 IN2.t2 ICTRL.t2 VSS.t0 nfet_06v0 ad=8.8p pd=40.88u as=8.8p ps=40.88u w=20u l=1u
X6 VIN.t11 IPB.t0 IPB.t1 VIN.t10 pfet_06v0 ad=8.8p pd=40.88u as=8.8p ps=40.88u w=20u l=4u
X7 VIN.t5 ICTRL.t4 SENSE.t0 VIN.t4 pfet_06v0 ad=44p pd=0.20088m as=44p ps=0.20088m w=100u l=10u
X8 ITAIL.t1 VSET.t0 IN1.t0 VIN.t7 pfet_06v0 ad=44p pd=0.20088m as=44p ps=0.20088m w=100u l=10u
X9 VIN.t9 IPB.t2 ITAIL.t2 VIN.t8 pfet_06v0 ad=8.8p pd=40.88u as=8.8p ps=40.88u w=20u l=4u
R0 IOUT IOUT.t0 42.5279
R1 ICTRL.n0 ICTRL.t3 104.13
R2 ICTRL.n0 ICTRL.t4 99.1807
R3 ICTRL.n1 ICTRL.t0 99.1807
R4 ICTRL.n2 ICTRL.t1 41.0168
R5 ICTRL.n3 ICTRL.t2 31.7324
R6 ICTRL.n1 ICTRL.n0 4.9505
R7 ICTRL.n3 ICTRL.n2 3.038
R8 ICTRL.n2 ICTRL.n1 1.184
R9 ICTRL ICTRL.n3 0.0905
R10 IN2.n0 IN2.t2 130.244
R11 IN2.n1 IN2.t1 41.4905
R12 IN2.n0 IN2.t0 35.619
R13 IN2.n1 IN2.n0 9.9005
R14 IN2 IN2.n1 0.0905
R15 SENSE.n0 SENSE.t1 101.076
R16 SENSE.n0 SENSE.t0 65.578
R17 SENSE SENSE.n0 0.0905
R18 VSET VSET.t0 101.639
R19 IPB.n0 IPB.t2 68.1472
R20 IPB.n0 IPB.t0 64.0972
R21 IPB.n1 IPB.t1 32.6627
R22 IPB.n1 IPB.n0 0.509
R23 IPB IPB.n1 0.0905
R24 VIN.n10 VIN.t10 131.619
R25 VIN.n8 VIN.t8 131.619
R26 VIN.n5 VIN.t6 99.7359
R27 VIN.n4 VIN.t2 99.7359
R28 VIN.n2 VIN.t4 99.7359
R29 VIN.n0 VIN.t0 99.7359
R30 VIN.n6 VIN.t7 99.7359
R31 VIN.n0 VIN.t1 47.2036
R32 VIN.n3 VIN.t3 44.3326
R33 VIN.n1 VIN.t5 44.3326
R34 VIN.n9 VIN.t11 35.0311
R35 VIN.n7 VIN.t9 35.0311
R36 VIN.n5 VIN.n4 18.9005
R37 VIN.n6 VIN.n5 4.9505
R38 VIN.n2 VIN.n1 2.8715
R39 VIN.n4 VIN.n3 2.8715
R40 VIN.n9 VIN.n8 2.5295
R41 VIN.n1 VIN.n0 2.0795
R42 VIN.n3 VIN.n2 2.0795
R43 VIN.n7 VIN.n6 1.8545
R44 VIN.n8 VIN.n7 1.5215
R45 VIN.n10 VIN.n9 1.5215
R46 VIN VIN.n10 0.0905
R47 VSS.n14 VSS.n13 621.611
R48 VSS.n4 VSS.n2 621.444
R49 VSS.n13 VSS.n1 621.444
R50 VSS.n15 VSS.n1 621.444
R51 VSS.n4 VSS.n3 621.444
R52 VSS.n10 VSS.n2 621.444
R53 VSS.n10 VSS.n3 621.444
R54 VSS.n6 VSS.n5 458.818
R55 VSS.n12 VSS.n11 316.796
R56 VSS.n12 VSS.t2 188.69
R57 VSS.n5 VSS.t4 188.69
R58 VSS.n11 VSS.t4 188.69
R59 VSS.n15 VSS.n14 144.732
R60 VSS.n16 VSS.n15 38.3025
R61 VSS.n10 VSS.n9 38.3025
R62 VSS.n8 VSS.t5 37.9874
R63 VSS.n0 VSS.t3 37.9874
R64 VSS.n7 VSS.t1 35.533
R65 VSS.n7 VSS.n6 35.0162
R66 VSS.n6 VSS.t0 33.7241
R67 VSS.n8 VSS.n7 2.9795
R68 VSS.n9 VSS.n8 2.8715
R69 VSS.n16 VSS.n0 2.8715
R70 VSS.n9 VSS.n0 2.0795
R71 VSS.n2 VSS.t4 0.217167
R72 VSS.n3 VSS.t4 0.217167
R73 VSS.t2 VSS.n1 0.217167
R74 VSS VSS.n16 0.0905
R75 VSS.n14 VSS.t2 0.0514603
R76 VSS.n11 VSS.n10 0.0477727
R77 VSS.n13 VSS.n12 0.0477727
R78 VSS.n5 VSS.n4 0.0477727
R79 IN1.n0 IN1.t3 73.0912
R80 IN1.n0 IN1.t1 68.1412
R81 IN1.n4 IN1.n3 40.0512
R82 IN1.n1 IN1.t2 34.198
R83 IN1.n4 IN1.n1 9.9005
R84 IN1.n1 IN1.n0 1.184
R85 IN1 IN1.n4 0.068
R86 IN1.n3 IN1.t0 0.0187
R87 IN1.n3 IN1.n2 0.0131
R88 ITAIL.n0 ITAIL.t0 45.4931
R89 ITAIL.n0 ITAIL.t1 40.5431
R90 ITAIL.n3 ITAIL.n2 31.1506
R91 ITAIL.n3 ITAIL.n0 5.7425
R92 ITAIL.n2 ITAIL.t2 0.0915
R93 ITAIL ITAIL.n3 0.068
R94 ITAIL.n2 ITAIL.n1 0.0635
C0 ITAIL IN1 0.69787f
C1 IN1 SENSE 0.06934f
C2 ITAIL IN2 0.16152f
C3 SENSE IN2 6.00496f
C4 ITAIL SENSE 5.60938f
C5 IN1 VSET 5.60882f
C6 VIN IPB 9.67213f
C7 ITAIL VSET 5.61115f
C8 VIN IOUT 11.1732f
C9 VIN ICTRL 39.3218f
C10 ICTRL IOUT 5.61736f
C11 IN1 VIN 11.1216f
C12 ITAIL IPB 1.39313f
C13 VIN IN2 11.1246f
C14 ITAIL VIN 22.8981f
C15 VIN SENSE 15.4297f
C16 IN2 ICTRL 1.17389f
C17 IN1 IN2 3.18532f
C18 VIN VSET 3.76258f
C19 SENSE ICTRL 5.76417f
C20 IOUT VSS 9.55742f
 ; **nodeattr IOUT : res:drive
C21 ICTRL VSS 41.8224f
 ; **nodeattr ICTRL : res:drive
C22 IN2 VSS 25.89093f
 ; **nodeattr IN2 : res:drive
C23 SENSE VSS 19.43284f
 ; **nodeattr SENSE : res:drive
C24 VSET VSS 11.49352f
 ; **nodeattr VSET : res:drive
C25 IPB VSS 17.11357f
 ; **nodeattr IPB : res:drive
C26 VIN VSS 0.93605p
 ; **nodeattr VIN : res:drive
C27 IN1 VSS 44.01263f
 ; **nodeattr IN1 : res:drive
C28 ITAIL VSS 21.65706f
 ; **nodeattr ITAIL : res:drive
C29 ITAIL.t0 VSS 23.82495f
C30 ITAIL.t1 VSS 17.53215f
C31 ITAIL.n0 VSS 7.38069f
C32 ITAIL.t2 VSS 1.9537f
C33 ITAIL.n1 VSS 0.21548f
C34 ITAIL.n2 VSS 3.19702f
C35 ITAIL.n3 VSS 2.75284f
C36 IN1.n0 VSS 2.25199f
C37 IN1.t2 VSS 4.6066f
C38 IN1.n1 VSS 0.45967f
C39 IN1.t0 VSS 6.67715f
C40 IN1.n2 VSS 0.13715f
C41 IN1.n3 VSS 1.06648f
C42 IN1.n4 VSS 0.51585f
C43 VSS.t3 VSS 3.78884f
C44 VSS.t1 VSS 0.98867f
C45 VSS.t5 VSS 3.82807f
C46 VIN.t1 VSS 8.5453f
C47 VIN.t0 VSS 17.7732f
C48 VIN.n0 VSS 4.64663f
C49 VIN.t5 VSS 8.46325f
C50 VIN.n1 VSS 0.4838f
C51 VIN.t4 VSS 17.7732f
C52 VIN.n2 VSS 4.21505f
C53 VIN.t3 VSS 8.46325f
C54 VIN.n3 VSS 0.4838f
C55 VIN.t2 VSS 17.7732f
C56 VIN.n4 VSS 4.4353f
C57 VIN.t6 VSS 17.7732f
C58 VIN.n5 VSS 4.46252f
C59 VIN.t7 VSS 17.7732f
C60 VIN.n6 VSS 4.23933f
C61 VIN.t9 VSS 2.14419f
C62 VIN.n7 VSS 0.35285f
C63 VIN.t8 VSS 1.94908f
C64 VIN.n8 VSS 1.4214f
C65 VIN.t11 VSS 2.10177f
C66 VIN.n9 VSS 0.36169f
C67 VIN.t10 VSS 1.94908f
C68 VIN.n10 VSS 1.38947f
C69 IPB.n0 VSS 2.77876f
C70 IPB.t1 VSS 2.71714f
C71 IPB.n1 VSS 0.6803f
C72 SENSE.t0 VSS 9.95966f
C73 SENSE.n0 VSS 5.21127f
C74 IN2.t0 VSS 7.95339f
C75 IN2.n0 VSS 5.89341f
C76 IN2.t1 VSS 19.38811f
C77 IN2.n1 VSS 2.63802f
C78 ICTRL.n0 VSS 4.50847f
C79 ICTRL.n1 VSS 2.28965f
C80 ICTRL.t1 VSS 8.44789f
C81 ICTRL.n2 VSS 0.44271f
C82 ICTRL.t2 VSS 1.45916f
C83 ICTRL.n3 VSS 0.31601f
C84 IOUT.t0 VSS 20.1247f
.ends
