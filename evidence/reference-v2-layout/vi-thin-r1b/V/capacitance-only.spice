* Explicit control derived from full raw RC; original RC retained.
.subckt nrz_vi_reference VIN VSS VSET SENSE IOUT IPB IN2 ICTRL
X0 VSS IN1 IN2 VSS nfet_06v0 ad=22p pd=0.10088m as=22p ps=0.10088m w=50u l=10u
X1 VSS IN1 IN1 VSS nfet_06v0 ad=22p pd=0.10088m as=22p ps=0.10088m w=50u l=10u
X2 VIN ICTRL IOUT VIN pfet_06v0 ad=44p pd=0.20088m as=44p ps=0.20088m w=100u l=10u
X3 VIN ICTRL ICTRL VIN pfet_06v0 ad=44p pd=0.20088m as=44p ps=0.20088m w=100u l=10u
X4 ITAIL SENSE IN2 VIN pfet_06v0 ad=44p pd=0.20088m as=44p ps=0.20088m w=100u l=10u
X5 VSS IN2 ICTRL VSS nfet_06v0 ad=8.8p pd=40.88u as=8.8p ps=40.88u w=20u l=1u
X6 VIN IPB IPB VIN pfet_06v0 ad=8.8p pd=40.88u as=8.8p ps=40.88u w=20u l=4u
X7 VIN ICTRL SENSE VIN pfet_06v0 ad=44p pd=0.20088m as=44p ps=0.20088m w=100u l=10u
X8 ITAIL VSET IN1 VIN pfet_06v0 ad=44p pd=0.20088m as=44p ps=0.20088m w=100u l=10u
X9 VIN IPB ITAIL VIN pfet_06v0 ad=8.8p pd=40.88u as=8.8p ps=40.88u w=20u l=4u
C0 ICTRL VSS 1.44984534892e-18
C1 ICTRL VSS 3.63448462891e-15
C2 ICTRL VSS 1.84579197168e-15
C3 ICTRL VSS 3.56887241369e-16
C4 ICTRL VSS 2.54746136751e-16
C5 ICTRL VSS 1.13802005136e-14
C6 ICTRL VSS 1.12013167372e-15
C7 ICTRL VSS 3.79281974613e-16
C8 ICTRL VSS 1.14674255005e-14
C9 ICTRL VSS 1.13802005136e-14
C10 IN1 VSS 4.53958360514e-18
C11 IN1 VSS 4.79192691616e-15
C12 IN1 VSS 9.78108548337e-16
C13 IN1 VSS 2.91830070635e-16
C14 IN1 VSS 2.26932367264e-15
C15 IN1 VSS 1.09765616533e-15
C16 IN1 VSS 4.21533979256e-16
C17 IN1 VSS 1.61242460378e-14
C18 IN1 VSS 1.74009427507e-15
C19 IN1 VSS 1.62912407511e-14
C20 IN2 VSS 1.07981652428e-17
C21 IN2 VSS 7.04529266152e-15
C22 IN2 VSS 3.15362802638e-15
C23 IN2 VSS 4.93162476773e-15
C24 IN2 VSS 8.37672806169e-15
C25 IN2 VSS 2.36382831743e-15
C26 IOUT VSS 1.30045383438e-15
C27 IOUT VSS 4.47863616562e-15
C28 IPB VSS 6.44468525874e-18
C29 IPB VSS 4.29659084541e-15
C30 IPB VSS 1.05189288113e-15
C31 IPB VSS 4.94798491735e-15
C32 IPB VSS 1.72731994315e-15
C33 IPB VSS 5.0791667277e-15
C34 ITAIL VSS 9.9718946181e-18
C35 ITAIL VSS 4.39140226904e-15
C36 ITAIL VSS 1.28209818668e-16
C37 ITAIL VSS 1.90217999701e-15
C38 ITAIL VSS 1.63789941351e-15
C39 ITAIL VSS 6.80901210685e-15
C40 ITAIL VSS 6.57643234168e-15
C41 ITAIL VSS 1.85192158626e-16
C42 SENSE VSS 1.85855715553e-18
C43 SENSE VSS 3.07971050071e-15
C44 SENSE VSS 1.71456111222e-15
C45 SENSE VSS 1.46335698299e-14
C46 VIN VSS 1.3289445362e-17
C47 VIN VSS 3.49346214132e-14
C48 VIN VSS 3.63736183935e-15
C49 VIN VSS 1.04464113594e-14
C50 VIN VSS 3.1689886216e-14
C51 VIN VSS 3.63736183935e-15
C52 VIN VSS 3.33457853012e-14
C53 VIN VSS 3.35504326251e-14
C54 VIN VSS 3.18724298246e-14
C55 VIN VSS 2.65282175806e-15
C56 VIN VSS 1.06864697376e-14
C57 VIN VSS 2.71927575131e-15
C58 VIN VSS 1.33623725862e-13
C59 VIN VSS 1.07721780217e-14
C60 VIN VSS 1.46537107332e-14
C61 VIN VSS 3.77226968582e-15
C62 VIN VSS 1.33623725862e-13
C63 VIN VSS 1.05620423602e-14
C64 VIN VSS 1.33623725862e-13
C65 VIN VSS 1.05620423602e-14
C66 VIN VSS 1.33623725862e-13
C67 VIN VSS 1.33623725862e-13
C68 VIN VSS 1.46537107332e-14
C69 VIN VSS 3.77226968582e-15
C70 VSET VSS 1.27944923615e-15
C71 VSET VSS 8.18966076385e-15
C72 IN1 SENSE 6.93405e-17
C73 VIN IN1 1.11216e-14
C74 IN1 IN2 3.18532e-15
C75 ITAIL VSET 5.61115e-15
C76 VIN SENSE 1.54297e-14
C77 SENSE IN2 6.00496e-15
C78 ITAIL IN1 6.97867e-16
C79 VIN IN2 1.11246e-14
C80 ICTRL SENSE 5.76417e-15
C81 VIN IPB 9.67213e-15
C82 ICTRL VIN 3.93218e-14
C83 ITAIL SENSE 5.60938e-15
C84 VSET IN1 5.60882e-15
C85 ICTRL IN2 1.17389e-15
C86 VIN ITAIL 2.28981e-14
C87 IOUT VIN 1.11732e-14
C88 ITAIL IN2 1.61524e-16
C89 IPB ITAIL 1.39313e-15
C90 VIN VSET 3.76258e-15
C91 ICTRL IOUT 5.61736e-15
.ends nrz_vi_reference
